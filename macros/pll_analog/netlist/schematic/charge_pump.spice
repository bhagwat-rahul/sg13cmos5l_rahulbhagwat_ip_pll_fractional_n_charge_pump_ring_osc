** sch_path: /foss/designs/current-designs/chipalooza2/sg13cmos5l_rahulbhagwat_ip_pll_fractional_n_charge_pump_ring_osc/macros/pll_analog/schematic/xschem/charge_pump.sch
.subckt charge_pump UP DOWN IREF VCTRL VDD VSS
*.PININFO UP:I DOWN:I IREF:B VCTRL:O VDD:B VSS:B
XM_UP_INV_P UP_B UP VDD VDD sg13_lv_pmos w=0.30u l=0.13u ng=1 m=1 mm_ok=1
XM_UP_INV_N UP_B UP VSS VSS sg13_lv_nmos w=0.15u l=0.13u ng=1 m=1 mm_ok=1
XM_IREF IREF IREF VSS VSS sg13_lv_nmos w=4.0u l=0.50u ng=4 m=1 mm_ok=1
XM_PBIAS PBIAS PBIAS VDD VDD sg13_lv_pmos w=8.0u l=0.50u ng=8 m=1 mm_ok=1
XM_PBIAS_SINK PBIAS IREF VSS VSS sg13_lv_nmos w=4.0u l=0.50u ng=4 m=1 mm_ok=1
XM_UP_SOURCE P_UP PBIAS VDD VDD sg13_lv_pmos w=7.0u l=0.50u ng=8 m=1 mm_ok=1
XM_UP_SWITCH VCTRL UP_B P_UP VDD sg13_lv_pmos w=1.0u l=0.13u ng=1 m=1 mm_ok=1
XM_DOWN_SWITCH VCTRL DOWN N_DOWN VSS sg13_lv_nmos w=1.5u l=0.13u ng=1 m=1 mm_ok=1
XM_DOWN_SINK N_DOWN IREF VSS VSS sg13_lv_nmos w=4.0u l=0.50u ng=4 m=1 mm_ok=1
.ends
