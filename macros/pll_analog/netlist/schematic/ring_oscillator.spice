** sch_path: /foss/designs/current-designs/chipalooza2/sg13cmos5l_rahulbhagwat_ip_pll_fractional_n_charge_pump_ring_osc/macros/pll_analog/schematic/xschem/ring_oscillator.sch
**.subckt ring_oscillator VDD VCO_OUT VCTRL VSS
*.ipin VCTRL
*.iopin VDD
*.iopin VSS
*.opin VCO_OUT
x1 VDD VBP VCO_CORE net1 VCTRL VSS inverter
x2 VDD VBP net1 net2 VCTRL VSS inverter
x3 VDD VBP net2 VCO_CORE VCTRL VSS inverter
x_bias VDD VBP VCTRL VSS vco_bias
x_buffer VDD VCO_CORE VCO_OUT VSS vco_buffer
**.ends

* expanding   symbol:  inverter.sym # of pins=6
** sym_path: /foss/designs/current-designs/chipalooza2/sg13cmos5l_rahulbhagwat_ip_pll_fractional_n_charge_pump_ring_osc/macros/pll_analog/schematic/xschem/inverter.sym
** sch_path: /foss/designs/current-designs/chipalooza2/sg13cmos5l_rahulbhagwat_ip_pll_fractional_n_charge_pump_ring_osc/macros/pll_analog/schematic/xschem/inverter.sch
.subckt inverter VDD VBP VIN VOUT VBN VSS
*.ipin VIN
*.ipin VBP
*.ipin VBN
*.opin VOUT
*.iopin VDD
*.iopin VSS
XM1 net1 VBP VDD VDD sg13_lv_pmos w=4.5u l=0.13u ng=5 m=1 mm_ok=1
XM2 VOUT VIN net1 VDD sg13_lv_pmos w=0.9u l=0.13u ng=1 m=1 mm_ok=1
XM3 VOUT VIN net2 VSS sg13_lv_nmos w=0.9u l=0.13u ng=1 m=1 mm_ok=1
XM4 net2 VBN VSS VSS sg13_lv_nmos w=4.5u l=0.13u ng=5 m=1 mm_ok=1
.ends

* expanding   symbol:  vco_bias.sym # of pins=4
** sym_path: /foss/designs/current-designs/chipalooza2/sg13cmos5l_rahulbhagwat_ip_pll_fractional_n_charge_pump_ring_osc/macros/pll_analog/schematic/xschem/vco_bias.sym
** sch_path: /foss/designs/current-designs/chipalooza2/sg13cmos5l_rahulbhagwat_ip_pll_fractional_n_charge_pump_ring_osc/macros/pll_analog/schematic/xschem/vco_bias.sch
.subckt vco_bias VDD VBP VCTRL VSS
*.ipin VCTRL
*.opin VBP
*.iopin VDD
*.iopin VSS
XM1 VBP VBP VDD VDD sg13_lv_pmos w=0.15u l=0.13u ng=1 m=1 mm_ok=1
XM2 VBP VCTRL VSS VSS sg13_lv_nmos w=0.15u l=0.13u ng=1 m=1 mm_ok=1
.ends

* expanding   symbol:  vco_buffer.sym # of pins=4
** sym_path: /foss/designs/current-designs/chipalooza2/sg13cmos5l_rahulbhagwat_ip_pll_fractional_n_charge_pump_ring_osc/macros/pll_analog/schematic/xschem/vco_buffer.sym
** sch_path: /foss/designs/current-designs/chipalooza2/sg13cmos5l_rahulbhagwat_ip_pll_fractional_n_charge_pump_ring_osc/macros/pll_analog/schematic/xschem/vco_buffer.sch
.subckt vco_buffer VDD VIN VOUT VSS
*.ipin VIN
*.opin VOUT
*.iopin VDD
*.iopin VSS
XM1 net1 VIN VDD VDD sg13_lv_pmos w=0.30u l=0.13u ng=1 m=1 mm_ok=1
XM2 net1 VIN VSS VSS sg13_lv_nmos w=0.15u l=0.13u ng=1 m=1 mm_ok=1
XM3 VOUT net1 VDD VDD sg13_lv_pmos w=0.90u l=0.13u ng=3 m=1 mm_ok=1
XM4 VOUT net1 VSS VSS sg13_lv_nmos w=0.45u l=0.13u ng=3 m=1 mm_ok=1
.ends

.end
