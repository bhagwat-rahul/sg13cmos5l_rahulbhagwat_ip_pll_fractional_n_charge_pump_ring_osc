** sch_path: /foss/designs/current-designs/chipalooza2/sg13cmos5l_rahulbhagwat_ip_pll_fractional_n_charge_pump_ring_osc/macros/pll_analog/schematic/xschem/inverter.sch
**.subckt inverter VDD VBP VIN VOUT VBN VSS
*.ipin VIN
*.ipin VBP
*.ipin VBN
*.opin VOUT
*.iopin VDD
*.iopin VSS
XM1 net1 VBP VDD VDD sg13_lv_pmos w=4.5u l=0.13u ng=5 m=1 mm_ok=1
XM2 VOUT VIN net1 VDD sg13_lv_pmos w=0.9u l=0.13u ng=1 m=1 mm_ok=1
XM3 VOUT VIN net2 VSS sg13_lv_nmos w=0.9u l=0.13u ng=1 m=1 mm_ok=1
XM4 net2 VBN VSS VSS sg13_lv_nmos w=4.5u l=0.13u ng=5 m=1 mm_ok=1
**.ends
.end
