** sch_path: /foss/designs/current-designs/chipalooza2/sg13cmos5l_rahulbhagwat_ip_pll_fractional_n_charge_pump_ring_osc/macros/pll_analog/schematic/xschem/pll_analog.sch
.subckt pll_analog UP DOWN IREF VCO_CLK VDD VSS
*.PININFO UP:I DOWN:I IREF:B VCO_CLK:O VDD:B VSS:B
x_charge_pump UP DOWN IREF VCTRL VDD VSS charge_pump
x_loop_filter VCTRL VSS loop_filter
x_vco VCTRL VCO_CLK VDD VSS ring_oscillator
.ends

* expanding   symbol:  charge_pump.sym # of pins=6
** sym_path: /foss/designs/current-designs/chipalooza2/sg13cmos5l_rahulbhagwat_ip_pll_fractional_n_charge_pump_ring_osc/macros/pll_analog/schematic/xschem/charge_pump.sym
** sch_path: /foss/designs/current-designs/chipalooza2/sg13cmos5l_rahulbhagwat_ip_pll_fractional_n_charge_pump_ring_osc/macros/pll_analog/schematic/xschem/charge_pump.sch
.subckt charge_pump UP DOWN IREF VCTRL VDD VSS
*.PININFO UP:I DOWN:I IREF:B VCTRL:O VDD:B VSS:B
XM_UP_INV_P UP_B UP VDD VDD sg13_lv_pmos w=0.30u l=0.13u ng=1 m=1 mm_ok=1
XM_UP_INV_N UP_B UP VSS VSS sg13_lv_nmos w=0.15u l=0.13u ng=1 m=1 mm_ok=1
XM_IREF IREF IREF VSS VSS sg13_lv_nmos w=4.0u l=0.50u ng=4 m=1 mm_ok=1
XM_PBIAS PBIAS PBIAS VDD VDD sg13_lv_pmos w=8.0u l=0.50u ng=8 m=1 mm_ok=1
XM_PBIAS_SINK PBIAS IREF VSS VSS sg13_lv_nmos w=4.0u l=0.50u ng=4 m=1 mm_ok=1
XM_UP_SOURCE P_UP PBIAS VDD VDD sg13_lv_pmos w=7.0u l=0.50u ng=8 m=1 mm_ok=1
XM_UP_SWITCH VCTRL UP_B P_UP VDD sg13_lv_pmos w=1.0u l=0.13u ng=1 m=1 mm_ok=1
XM_DOWN_SWITCH VCTRL DOWN N_DOWN VSS sg13_lv_nmos w=1.5u l=0.13u ng=1 m=1 mm_ok=1
XM_DOWN_SINK N_DOWN IREF VSS VSS sg13_lv_nmos w=4.0u l=0.50u ng=4 m=1 mm_ok=1
.ends

* expanding   symbol:  loop_filter.sym # of pins=2
** sym_path: /foss/designs/current-designs/chipalooza2/sg13cmos5l_rahulbhagwat_ip_pll_fractional_n_charge_pump_ring_osc/macros/pll_analog/schematic/xschem/loop_filter.sym
** sch_path: /foss/designs/current-designs/chipalooza2/sg13cmos5l_rahulbhagwat_ip_pll_fractional_n_charge_pump_ring_osc/macros/pll_analog/schematic/xschem/loop_filter.sch
.subckt loop_filter VCTRL VSS
*.PININFO VCTRL:B VSS:B
XR1 VCTRL FILTER_ZERO VSS rhigh w=1.0u l=22.08u m=1 b=0 mm_ok=1
XC1A FILTER_ZERO VSS cap_cmomf w=100u l=100u mmin=2 mmax=4 subblock=0 m=1 mm_ok=1
XC2 VCTRL VSS cap_cmomf w=32.6431u l=32.6431u mmin=2 mmax=4 subblock=0 m=1 mm_ok=1
**** begin user architecture code

.lib cornerRES.lib res_typ
.include cap_cmomf.lib

**** end user architecture code
.ends

* expanding   symbol:  ring_oscillator.sym # of pins=4
** sym_path: /foss/designs/current-designs/chipalooza2/sg13cmos5l_rahulbhagwat_ip_pll_fractional_n_charge_pump_ring_osc/macros/pll_analog/schematic/xschem/ring_oscillator.sym
** sch_path: /foss/designs/current-designs/chipalooza2/sg13cmos5l_rahulbhagwat_ip_pll_fractional_n_charge_pump_ring_osc/macros/pll_analog/schematic/xschem/ring_oscillator.sch
.subckt ring_oscillator VCTRL VCO_OUT VDD VSS
*.PININFO VCTRL:I VDD:B VSS:B VCO_OUT:O
x1 VCO_CORE net1 VBP VDD VCTRL VSS inverter
x2 net1 net2 VBP VDD VCTRL VSS inverter
x3 net2 VCO_CORE VBP VDD VCTRL VSS inverter
x_bias VCTRL VBP VDD VSS vco_bias
x_buffer VCO_CORE VCO_OUT VDD VSS vco_buffer
.ends

* expanding   symbol:  inverter.sym # of pins=6
** sym_path: /foss/designs/current-designs/chipalooza2/sg13cmos5l_rahulbhagwat_ip_pll_fractional_n_charge_pump_ring_osc/macros/pll_analog/schematic/xschem/inverter.sym
** sch_path: /foss/designs/current-designs/chipalooza2/sg13cmos5l_rahulbhagwat_ip_pll_fractional_n_charge_pump_ring_osc/macros/pll_analog/schematic/xschem/inverter.sch
.subckt inverter VIN VOUT VBP VDD VBN VSS
*.PININFO VIN:I VBP:I VBN:I VOUT:O VDD:B VSS:B
XM1 net1 VBP VDD VDD sg13_lv_pmos w=4.5u l=0.13u ng=5 m=1 mm_ok=1
XM2 VOUT VIN net1 VDD sg13_lv_pmos w=0.9u l=0.13u ng=1 m=1 mm_ok=1
XM3 VOUT VIN net2 VSS sg13_lv_nmos w=0.9u l=0.13u ng=1 m=1 mm_ok=1
XM4 net2 VBN VSS VSS sg13_lv_nmos w=4.5u l=0.13u ng=5 m=1 mm_ok=1
.ends

* expanding   symbol:  vco_bias.sym # of pins=4
** sym_path: /foss/designs/current-designs/chipalooza2/sg13cmos5l_rahulbhagwat_ip_pll_fractional_n_charge_pump_ring_osc/macros/pll_analog/schematic/xschem/vco_bias.sym
** sch_path: /foss/designs/current-designs/chipalooza2/sg13cmos5l_rahulbhagwat_ip_pll_fractional_n_charge_pump_ring_osc/macros/pll_analog/schematic/xschem/vco_bias.sch
.subckt vco_bias VCTRL VBP VDD VSS
*.PININFO VCTRL:I VBP:O VDD:B VSS:B
XM1 VBP VBP VDD VDD sg13_lv_pmos w=0.15u l=0.13u ng=1 m=1 mm_ok=1
XM2 VBP VCTRL VSS VSS sg13_lv_nmos w=0.15u l=0.13u ng=1 m=1 mm_ok=1
.ends

* expanding   symbol:  vco_buffer.sym # of pins=4
** sym_path: /foss/designs/current-designs/chipalooza2/sg13cmos5l_rahulbhagwat_ip_pll_fractional_n_charge_pump_ring_osc/macros/pll_analog/schematic/xschem/vco_buffer.sym
** sch_path: /foss/designs/current-designs/chipalooza2/sg13cmos5l_rahulbhagwat_ip_pll_fractional_n_charge_pump_ring_osc/macros/pll_analog/schematic/xschem/vco_buffer.sch
.subckt vco_buffer VIN VOUT VDD VSS
*.PININFO VIN:I VOUT:O VDD:B VSS:B
XM1 net1 VIN VDD VDD sg13_lv_pmos w=0.30u l=0.13u ng=1 m=1 mm_ok=1
XM2 net1 VIN VSS VSS sg13_lv_nmos w=0.15u l=0.13u ng=1 m=1 mm_ok=1
XM3 VOUT net1 VDD VDD sg13_lv_pmos w=0.90u l=0.13u ng=3 m=1 mm_ok=1
XM4 VOUT net1 VSS VSS sg13_lv_nmos w=0.45u l=0.13u ng=3 m=1 mm_ok=1
.ends
