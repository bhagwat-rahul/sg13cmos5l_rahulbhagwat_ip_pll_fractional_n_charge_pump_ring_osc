** sch_path: /foss/designs/current-designs/chipalooza2/sg13cmos5l_rahulbhagwat_ip_pll_fractional_n_charge_pump_ring_osc/macros/pll_analog/schematic/xschem/pll_cosim.sch
**.subckt pll_cosim VDD VSS REF_CLK IREF ENABLE RESET_N TEST_CLK
*+ DIV_RATIO9,DIV_RATIO8,DIV_RATIO7,DIV_RATIO6,DIV_RATIO5,DIV_RATIO4,DIV_RATIO3,DIV_RATIO2,DIV_RATIO1,DIV_RATIO0 TEST_DIV1,TEST_DIV0
*.ipin REF_CLK
*.iopin IREF
*.ipin ENABLE
*.ipin RESET_N
*.ipin DIV_RATIO9,DIV_RATIO8,DIV_RATIO7,DIV_RATIO6,DIV_RATIO5,DIV_RATIO4,DIV_RATIO3,DIV_RATIO2,DIV_RATIO1,DIV_RATIO0
*.ipin TEST_DIV1,TEST_DIV0
*.opin TEST_CLK
*.iopin VDD
*.iopin VSS
a_digital [ REF_CLK VCO_CLK RESET_N ENABLE TEST_DIV1 TEST_DIV0 DIV_RATIO9 DIV_RATIO8 DIV_RATIO7 DIV_RATIO6 DIV_RATIO5 DIV_RATIO4
+ DIV_RATIO3 DIV_RATIO2 DIV_RATIO1 DIV_RATIO0 ] [ FB_CLK UP DOWN PLL_CLK TEST_CLK ] pll_digital_cosim
x_analog VDD UP VCO_CLK DOWN IREF VSS pll_analog
**.ends

* expanding   symbol:  pll_analog.sym # of pins=6
** sym_path: /foss/designs/current-designs/chipalooza2/sg13cmos5l_rahulbhagwat_ip_pll_fractional_n_charge_pump_ring_osc/macros/pll_analog/schematic/xschem/pll_analog.sym
** sch_path: /foss/designs/current-designs/chipalooza2/sg13cmos5l_rahulbhagwat_ip_pll_fractional_n_charge_pump_ring_osc/macros/pll_analog/schematic/xschem/pll_analog.sch
.subckt pll_analog VDD UP VCO_CLK DOWN IREF VSS
*.ipin UP
*.ipin DOWN
*.iopin IREF
*.opin VCO_CLK
*.iopin VDD
*.iopin VSS
x_charge_pump VDD UP DOWN IREF net1 VSS charge_pump
x_loop_filter net1 VSS loop_filter
x_vco VDD VCO_CLK net1 VSS ring_oscillator
.ends

* expanding   symbol:  charge_pump.sym # of pins=6
** sym_path: /foss/designs/current-designs/chipalooza2/sg13cmos5l_rahulbhagwat_ip_pll_fractional_n_charge_pump_ring_osc/macros/pll_analog/schematic/xschem/charge_pump.sym
** sch_path: /foss/designs/current-designs/chipalooza2/sg13cmos5l_rahulbhagwat_ip_pll_fractional_n_charge_pump_ring_osc/macros/pll_analog/schematic/xschem/charge_pump.sch
.subckt charge_pump VDD UP DOWN IREF VCTRL VSS
*.ipin UP
*.ipin DOWN
*.iopin IREF
*.opin VCTRL
*.iopin VDD
*.iopin VSS
*  M_UP_INV_P -  sg13_lv_pmos  IS MISSING !!!!
*  M_UP_INV_N -  sg13_lv_nmos  IS MISSING !!!!
*  M_IREF -  sg13_lv_nmos  IS MISSING !!!!
*  M_PBIAS -  sg13_lv_pmos  IS MISSING !!!!
*  M_PBIAS_SINK -  sg13_lv_nmos  IS MISSING !!!!
*  M_UP_SOURCE -  sg13_lv_pmos  IS MISSING !!!!
*  M_UP_SWITCH -  sg13_lv_pmos  IS MISSING !!!!
*  M_DOWN_SWITCH -  sg13_lv_nmos  IS MISSING !!!!
*  M_DOWN_SINK -  sg13_lv_nmos  IS MISSING !!!!
.ends

* expanding   symbol:  loop_filter.sym # of pins=2
** sym_path: /foss/designs/current-designs/chipalooza2/sg13cmos5l_rahulbhagwat_ip_pll_fractional_n_charge_pump_ring_osc/macros/pll_analog/schematic/xschem/loop_filter.sym
** sch_path: /foss/designs/current-designs/chipalooza2/sg13cmos5l_rahulbhagwat_ip_pll_fractional_n_charge_pump_ring_osc/macros/pll_analog/schematic/xschem/loop_filter.sch
.subckt loop_filter VCTRL VSS
*.iopin VCTRL
*.iopin VSS
*  R1 -  rhigh  IS MISSING !!!!
*  C1A -  cap_cmomf  IS MISSING !!!!
*  C2 -  cap_cmomf  IS MISSING !!!!
**** begin user architecture code

.lib cornerRES.lib res_typ
.include cap_cmomf.lib

**** end user architecture code
.ends

* expanding   symbol:  ring_oscillator.sym # of pins=4
** sym_path: /foss/designs/current-designs/chipalooza2/sg13cmos5l_rahulbhagwat_ip_pll_fractional_n_charge_pump_ring_osc/macros/pll_analog/schematic/xschem/ring_oscillator.sym
** sch_path: /foss/designs/current-designs/chipalooza2/sg13cmos5l_rahulbhagwat_ip_pll_fractional_n_charge_pump_ring_osc/macros/pll_analog/schematic/xschem/ring_oscillator.sch
.subckt ring_oscillator VDD VCO_OUT VCTRL VSS
*.ipin VCTRL
*.iopin VDD
*.iopin VSS
*.opin VCO_OUT
x1 VDD VBP VCO_CORE net1 VCTRL VSS inverter
x2 VDD VBP net1 net2 VCTRL VSS inverter
x3 VDD VBP net2 VCO_CORE VCTRL VSS inverter
x_bias VDD VBP VCTRL VSS vco_bias
x_buffer VDD VCO_CORE VCO_OUT VSS vco_buffer
.ends

* expanding   symbol:  inverter.sym # of pins=6
** sym_path: /foss/designs/current-designs/chipalooza2/sg13cmos5l_rahulbhagwat_ip_pll_fractional_n_charge_pump_ring_osc/macros/pll_analog/schematic/xschem/inverter.sym
** sch_path: /foss/designs/current-designs/chipalooza2/sg13cmos5l_rahulbhagwat_ip_pll_fractional_n_charge_pump_ring_osc/macros/pll_analog/schematic/xschem/inverter.sch
.subckt inverter VDD VBP VIN VOUT VBN VSS
*.ipin VIN
*.ipin VBP
*.ipin VBN
*.opin VOUT
*.iopin VDD
*.iopin VSS
*  M1 -  sg13_lv_pmos  IS MISSING !!!!
*  M2 -  sg13_lv_pmos  IS MISSING !!!!
*  M3 -  sg13_lv_nmos  IS MISSING !!!!
*  M4 -  sg13_lv_nmos  IS MISSING !!!!
.ends

* expanding   symbol:  vco_bias.sym # of pins=4
** sym_path: /foss/designs/current-designs/chipalooza2/sg13cmos5l_rahulbhagwat_ip_pll_fractional_n_charge_pump_ring_osc/macros/pll_analog/schematic/xschem/vco_bias.sym
** sch_path: /foss/designs/current-designs/chipalooza2/sg13cmos5l_rahulbhagwat_ip_pll_fractional_n_charge_pump_ring_osc/macros/pll_analog/schematic/xschem/vco_bias.sch
.subckt vco_bias VDD VBP VCTRL VSS
*.ipin VCTRL
*.opin VBP
*.iopin VDD
*.iopin VSS
*  M1 -  sg13_lv_pmos  IS MISSING !!!!
*  M2 -  sg13_lv_nmos  IS MISSING !!!!
.ends

* expanding   symbol:  vco_buffer.sym # of pins=4
** sym_path: /foss/designs/current-designs/chipalooza2/sg13cmos5l_rahulbhagwat_ip_pll_fractional_n_charge_pump_ring_osc/macros/pll_analog/schematic/xschem/vco_buffer.sym
** sch_path: /foss/designs/current-designs/chipalooza2/sg13cmos5l_rahulbhagwat_ip_pll_fractional_n_charge_pump_ring_osc/macros/pll_analog/schematic/xschem/vco_buffer.sch
.subckt vco_buffer VDD VIN VOUT VSS
*.ipin VIN
*.opin VOUT
*.iopin VDD
*.iopin VSS
*  M1 -  sg13_lv_pmos  IS MISSING !!!!
*  M2 -  sg13_lv_nmos  IS MISSING !!!!
*  M3 -  sg13_lv_pmos  IS MISSING !!!!
*  M4 -  sg13_lv_nmos  IS MISSING !!!!
.ends

**** begin user architecture code
.model pll_digital_cosim d_cosim simulation=./pll_digital_cosim.so delay=1e-12
**** end user architecture code
.end
