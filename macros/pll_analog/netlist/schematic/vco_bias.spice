** sch_path: /foss/designs/current-designs/chipalooza2/sg13cmos5l_rahulbhagwat_ip_pll_fractional_n_charge_pump_ring_osc/macros/pll_analog/schematic/xschem/vco_bias.sch
**.subckt vco_bias VDD VBP VCTRL VSS
*.ipin VCTRL
*.opin VBP
*.iopin VDD
*.iopin VSS
XM1 VBP VBP VDD VDD sg13_lv_pmos w=0.15u l=0.13u ng=1 m=1 mm_ok=1
XM2 VBP VCTRL VSS VSS sg13_lv_nmos w=0.15u l=0.13u ng=1 m=1 mm_ok=1
**.ends
.end
