* NGSPICE file created from pll_digital.ext - technology: ihp-sg13cmos5l

* Black-box entry subcircuit for sg13cmos5l_decap_4 abstract view
.subckt sg13cmos5l_decap_4 VDD VSS
.ends

* Black-box entry subcircuit for sg13cmos5l_fill_1 abstract view
.subckt sg13cmos5l_fill_1 VDD VSS
.ends

* Black-box entry subcircuit for sg13cmos5l_decap_8 abstract view
.subckt sg13cmos5l_decap_8 VDD VSS
.ends

* Black-box entry subcircuit for sg13cmos5l_a21oi_1 abstract view
.subckt sg13cmos5l_a21oi_1 Y A1 A2 B1 VDD VSS
.ends

* Black-box entry subcircuit for sg13cmos5l_a22oi_1 abstract view
.subckt sg13cmos5l_a22oi_1 Y A1 A2 B1 B2 VDD VSS
.ends

* Black-box entry subcircuit for sg13cmos5l_fill_2 abstract view
.subckt sg13cmos5l_fill_2 VDD VSS
.ends

* Black-box entry subcircuit for sg13cmos5l_buf_8 abstract view
.subckt sg13cmos5l_buf_8 X A VDD VSS
.ends

* Black-box entry subcircuit for sg13cmos5l_nor4_1 abstract view
.subckt sg13cmos5l_nor4_1 Y A B C D VDD VSS
.ends

* Black-box entry subcircuit for sg13cmos5l_inv_4 abstract view
.subckt sg13cmos5l_inv_4 Y A VDD VSS
.ends

* Black-box entry subcircuit for sg13cmos5l_nand3_1 abstract view
.subckt sg13cmos5l_nand3_1 Y A B C VDD VSS
.ends

* Black-box entry subcircuit for sg13cmos5l_dfrbpq_2 abstract view
.subckt sg13cmos5l_dfrbpq_2 Q CLK D RESET_B VDD VSS
.ends

* Black-box entry subcircuit for sg13cmos5l_o21ai_1 abstract view
.subckt sg13cmos5l_o21ai_1 Y A1 A2 B1 VDD VSS
.ends

* Black-box entry subcircuit for sg13cmos5l_inv_2 abstract view
.subckt sg13cmos5l_inv_2 Y A VDD VSS
.ends

* Black-box entry subcircuit for sg13cmos5l_nand2_1 abstract view
.subckt sg13cmos5l_nand2_1 Y A B VDD VSS
.ends

* Black-box entry subcircuit for sg13cmos5l_buf_16 abstract view
.subckt sg13cmos5l_buf_16 X A VDD VSS
.ends

* Black-box entry subcircuit for sg13cmos5l_nand2b_1 abstract view
.subckt sg13cmos5l_nand2b_1 Y A_N B VDD VSS
.ends

* Black-box entry subcircuit for sg13cmos5l_nor2b_1 abstract view
.subckt sg13cmos5l_nor2b_1 Y A B_N VDD VSS
.ends

* Black-box entry subcircuit for sg13cmos5l_dfrbp_2 abstract view
.subckt sg13cmos5l_dfrbp_2 Q Q_N CLK D RESET_B VDD VSS
.ends

* Black-box entry subcircuit for sg13cmos5l_inv_16 abstract view
.subckt sg13cmos5l_inv_16 Y A VDD VSS
.ends

* Black-box entry subcircuit for sg13cmos5l_nor2_1 abstract view
.subckt sg13cmos5l_nor2_1 Y A B VDD VSS
.ends

* Black-box entry subcircuit for sg13cmos5l_buf_2 abstract view
.subckt sg13cmos5l_buf_2 X A VDD VSS
.ends

* Black-box entry subcircuit for sg13cmos5l_nor3_1 abstract view
.subckt sg13cmos5l_nor3_1 Y A B C VDD VSS
.ends

* Black-box entry subcircuit for sg13cmos5l_buf_1 abstract view
.subckt sg13cmos5l_buf_1 X A VDD VSS
.ends

* Black-box entry subcircuit for sg13cmos5l_nand4_1 abstract view
.subckt sg13cmos5l_nand4_1 Y A B C D VDD VSS
.ends

* Black-box entry subcircuit for sg13cmos5l_and2_2 abstract view
.subckt sg13cmos5l_and2_2 X A B VDD VSS
.ends

* Black-box entry subcircuit for sg13cmos5l_and4_1 abstract view
.subckt sg13cmos5l_and4_1 X A B C D VDD VSS
.ends

* Black-box entry subcircuit for sg13cmos5l_tielo abstract view
.subckt sg13cmos5l_tielo L_LO VDD VSS
.ends

* Black-box entry subcircuit for sg13cmos5l_and2_1 abstract view
.subckt sg13cmos5l_and2_1 X A B VDD VSS
.ends

* Black-box entry subcircuit for sg13cmos5l_nand2b_2 abstract view
.subckt sg13cmos5l_nand2b_2 Y A_N B VDD VSS
.ends

* Black-box entry subcircuit for sg13cmos5l_a221oi_1 abstract view
.subckt sg13cmos5l_a221oi_1 Y A1 A2 B1 B2 C1 VDD VSS
.ends

* Black-box entry subcircuit for sg13cmos5l_mux4_1 abstract view
.subckt sg13cmos5l_mux4_1 X A0 A1 A2 A3 S0 S1 VDD VSS
.ends

* Black-box entry subcircuit for sg13cmos5l_tiehi abstract view
.subckt sg13cmos5l_tiehi L_HI VDD VSS
.ends

* Black-box entry subcircuit for sg13cmos5l_nand3b_1 abstract view
.subckt sg13cmos5l_nand3b_1 Y A_N B C VDD VSS
.ends

* Black-box entry subcircuit for sg13cmos5l_or2_1 abstract view
.subckt sg13cmos5l_or2_1 X A B VDD VSS
.ends

.subckt pll_digital VDD VSS div_ratio[0] div_ratio[1] div_ratio[2] div_ratio[3] div_ratio[4]
+ div_ratio[5] div_ratio[6] div_ratio[7] div_ratio[8] div_ratio[9] down enable feedback_clk
+ pll_clk ref_clk reset_n test_clk test_div_select[0] test_div_select[1] up vco_clk
XFILLER_7_7 VDD VSS sg13cmos5l_decap_4
XFILLER_13_155 VDD VSS sg13cmos5l_fill_1
XFILLER_3_78 VDD VSS sg13cmos5l_decap_8
Xfeedback_divider_i._418_ feedback_divider_i._418_/Y feedback_divider_i._498_/Q feedback_divider_i._291_/A
+ feedback_divider_i._537_/Q VDD VSS sg13cmos5l_a21oi_1
XFILLER_8_170 VDD VSS sg13cmos5l_decap_8
XFILLER_8_181 VDD VSS sg13cmos5l_fill_1
Xfeedback_divider_i._349_ feedback_divider_i._349_/Y feedback_divider_i._574_/Q feedback_divider_i._585_/Q
+ feedback_divider_i._584_/Q feedback_divider_i._573_/Q VDD VSS sg13cmos5l_a22oi_1
XFILLER_18_203 VDD VSS sg13cmos5l_decap_4
XFILLER_18_247 VDD VSS sg13cmos5l_fill_2
XFILLER_2_302 VDD VSS sg13cmos5l_decap_8
Xclkbuf_2_2_0_pll_clk_regs clkbuf_3_5_0_pll_clk_regs/A clkbuf_2_3_0_pll_clk_regs/A
+ VDD VSS sg13cmos5l_buf_8
Xfeedback_divider_i.configuration_decode_i._141_ feedback_divider_i._309_/A fanout55/X
+ fanout13/X fanout53/X feedback_divider_i.configuration_decode_i._141_/D VDD VSS
+ sg13cmos5l_nor4_1
Xoutput_divider_i.vco_input_buffer.input_inverter_72 output_divider_i.vco_input_buffer.input_inverter_72/Y
+ vco_clk VDD VSS sg13cmos5l_inv_4
Xfeedback_divider_i.configuration_decode_i._072_ feedback_divider_i._261_/A feedback_divider_i.configuration_decode_i._072_/A
+ fanout20/X feedback_divider_i.configuration_decode_i._072_/C VDD VSS sg13cmos5l_nand3_1
XFILLER_17_280 VDD VSS sg13cmos5l_fill_1
XFILLER_24_239 VDD VSS sg13cmos5l_fill_2
XFILLER_15_206 VDD VSS sg13cmos5l_decap_8
XFILLER_23_283 VDD VSS sg13cmos5l_fill_1
XFILLER_23_53 VDD VSS sg13cmos5l_decap_8
Xfeedback_divider_i.configuration_decode_i._124_ feedback_divider_i._294_/A fanout45/X
+ fanout51/X feedback_divider_i.configuration_decode_i._146_/A fanout14/X VDD VSS
+ sg13cmos5l_nor4_1
Xfeedback_divider_i.configuration_decode_i._055_ feedback_divider_i.configuration_decode_i._055_/Y
+ fanout62/X input3/X fanout59/X fanout57/X VDD VSS sg13cmos5l_a22oi_1
XFILLER_0_35 VDD VSS sg13cmos5l_decap_4
XFILLER_14_294 VDD VSS sg13cmos5l_decap_8
XFILLER_17_9 VDD VSS sg13cmos5l_fill_2
XFILLER_2_132 VDD VSS sg13cmos5l_fill_1
XFILLER_11_220 VDD VSS sg13cmos5l_fill_2
XFILLER_11_253 VDD VSS sg13cmos5l_fill_1
XFILLER_18_42 VDD VSS sg13cmos5l_fill_1
XFILLER_22_7 VDD VSS sg13cmos5l_decap_8
Xclkbuf_4_5_0_pll_clk_regs clkbuf_4_5_0_pll_clk_regs/X clkbuf_4_5_0_pll_clk_regs/A
+ VDD VSS sg13cmos5l_buf_8
Xfeedback_divider_i.configuration_decode_i._107_ feedback_divider_i._279_/A fanout46/X
+ fanout52/X feedback_divider_i.configuration_decode_i._147_/A fanout16/X VDD VSS
+ sg13cmos5l_nor4_1
Xfeedback_divider_i._597_ feedback_clk feedback_divider_i._597_/CLK feedback_divider_i._597_/D
+ fanout33/X VDD VSS sg13cmos5l_dfrbpq_2
XFILLER_20_87 VDD VSS sg13cmos5l_decap_4
XFILLER_4_205 VDD VSS sg13cmos5l_fill_1
Xfeedback_divider_i._520_ feedback_divider_i._520_/Q clkbuf_4_2_0_pll_clk_regs/X feedback_divider_i._520_/D
+ fanout23/X VDD VSS sg13cmos5l_dfrbpq_2
Xfeedback_divider_i._451_ feedback_divider_i._522_/D feedback_divider_i._493_/Q feedback_divider_i._308_/Y
+ feedback_divider_i._450_/Y VDD VSS sg13cmos5l_o21ai_1
Xfeedback_divider_i._382_ feedback_divider_i._382_/Y feedback_divider_i._502_/Q feedback_divider_i._273_/A
+ feedback_divider_i._555_/Q VDD VSS sg13cmos5l_a21oi_1
XFILLER_25_153 VDD VSS sg13cmos5l_fill_1
XFILLER_25_197 VDD VSS sg13cmos5l_decap_8
XFILLER_9_308 VDD VSS sg13cmos5l_fill_1
XFILLER_0_230 VDD VSS sg13cmos5l_decap_8
XFILLER_16_142 VDD VSS sg13cmos5l_fill_1
Xfeedback_divider_i._296_ feedback_divider_i._296_/Y feedback_divider_i._296_/A VDD
+ VSS sg13cmos5l_inv_2
Xfeedback_divider_i._503_ feedback_divider_i._503_/Q feedback_divider_i._561_/CLK
+ feedback_divider_i._503_/D fanout35/X VDD VSS sg13cmos5l_dfrbpq_2
Xfeedback_divider_i._434_ feedback_divider_i._434_/Y feedback_divider_i._496_/Q feedback_divider_i._299_/A
+ feedback_divider_i._529_/Q VDD VSS sg13cmos5l_a21oi_1
Xfeedback_divider_i._365_ feedback_divider_i._565_/D feedback_divider_i._503_/Q feedback_divider_i._265_/Y
+ feedback_divider_i._364_/Y VDD VSS sg13cmos5l_o21ai_1
XFILLER_22_178 VDD VSS sg13cmos5l_decap_4
Xfeedback_divider_i._279_ feedback_divider_i._279_/Y feedback_divider_i._279_/A VDD
+ VSS sg13cmos5l_inv_2
Xfeedback_divider_i._348_ feedback_divider_i._586_/D feedback_divider_i._572_/Q feedback_divider_i._256_/Y
+ feedback_divider_i._347_/Y VDD VSS sg13cmos5l_o21ai_1
Xfeedback_divider_i._417_ feedback_divider_i._539_/D feedback_divider_i._497_/Q feedback_divider_i._291_/Y
+ feedback_divider_i._416_/Y VDD VSS sg13cmos5l_o21ai_1
XFILLER_10_137 VDD VSS sg13cmos5l_decap_8
XFILLER_12_55 VDD VSS sg13cmos5l_fill_1
XFILLER_12_77 VDD VSS sg13cmos5l_fill_1
Xfeedback_divider_i.configuration_decode_i._140_ fanout13/A fanout60/X fanout40/X
+ VDD VSS sg13cmos5l_nand2_1
Xfeedback_divider_i.configuration_decode_i._071_ feedback_divider_i._260_/A feedback_divider_i.configuration_decode_i._072_/A
+ fanout20/X feedback_divider_i.configuration_decode_i._072_/C VDD VSS sg13cmos5l_a21oi_1
XFILLER_15_229 VDD VSS sg13cmos5l_decap_4
XFILLER_23_32 VDD VSS sg13cmos5l_fill_1
XFILLER_0_14 VDD VSS sg13cmos5l_decap_8
XFILLER_14_273 VDD VSS sg13cmos5l_decap_8
XFILLER_2_100 VDD VSS sg13cmos5l_fill_1
XFILLER_2_188 VDD VSS sg13cmos5l_decap_8
XFILLER_9_56 VDD VSS sg13cmos5l_decap_4
Xclkbuf_4_13_0_pll_clk_regs feedback_divider_i._588_/CLK clkbuf_3_6_0_pll_clk_regs/X
+ VDD VSS sg13cmos5l_buf_8
Xfeedback_divider_i.configuration_decode_i._123_ feedback_divider_i._293_/A fanout56/X
+ fanout14/X fanout54/X feedback_divider_i.configuration_decode_i._141_/D VDD VSS
+ sg13cmos5l_nor4_1
Xfeedback_divider_i.configuration_decode_i._054_ feedback_divider_i.configuration_decode_i._054_/Y
+ fanout62/X fanout58/X VDD VSS sg13cmos5l_nand2_1
XFILLER_20_232 VDD VSS sg13cmos5l_decap_4
XFILLER_20_265 VDD VSS sg13cmos5l_fill_1
XFILLER_11_232 VDD VSS sg13cmos5l_decap_8
XFILLER_11_243 VDD VSS sg13cmos5l_fill_1
Xclkbuf_0_output_divider_i.div4_clk_regs clkbuf_0_output_divider_i.div4_clk_regs/X
+ clkbuf_regs_1_div4/X VDD VSS sg13cmos5l_buf_16
Xfeedback_divider_i.configuration_decode_i._106_ feedback_divider_i._278_/A fanout46/X
+ fanout52/X feedback_divider_i.configuration_decode_i._146_/A fanout16/X VDD VSS
+ sg13cmos5l_nor4_1
Xfeedback_divider_i._596_ feedback_divider_i._596_/Q clkbuf_4_4_0_pll_clk_regs/X feedback_divider_i._596_/D
+ fanout24/X VDD VSS sg13cmos5l_dfrbpq_2
Xfeedback_divider_i._450_ feedback_divider_i._450_/Y feedback_divider_i._494_/Q feedback_divider_i._307_/A
+ feedback_divider_i._521_/Q VDD VSS sg13cmos5l_a21oi_1
Xfeedback_divider_i._381_ feedback_divider_i._557_/D feedback_divider_i._501_/Q feedback_divider_i._273_/Y
+ feedback_divider_i._380_/Y VDD VSS sg13cmos5l_o21ai_1
XFILLER_19_140 VDD VSS sg13cmos5l_fill_1
XFILLER_6_35 VDD VSS sg13cmos5l_decap_8
Xfeedback_divider_i._579_ feedback_divider_i._579_/Q clkbuf_4_4_0_pll_clk_regs/X feedback_divider_i._579_/D
+ fanout24/X VDD VSS sg13cmos5l_dfrbpq_2
XFILLER_25_132 VDD VSS sg13cmos5l_decap_8
XFILLER_15_88 VDD VSS sg13cmos5l_fill_2
Xfeedback_divider_i._295_ feedback_divider_i._295_/Y feedback_divider_i._295_/A VDD
+ VSS sg13cmos5l_inv_2
Xfeedback_divider_i._502_ feedback_divider_i._502_/Q clkbuf_4_4_0_pll_clk_regs/X feedback_divider_i._504_/D
+ fanout24/X VDD VSS sg13cmos5l_dfrbpq_2
Xfeedback_divider_i._433_ feedback_divider_i._531_/D feedback_divider_i._495_/Q feedback_divider_i._299_/Y
+ feedback_divider_i._432_/Y VDD VSS sg13cmos5l_o21ai_1
Xfeedback_divider_i._364_ feedback_divider_i._364_/Y feedback_divider_i._504_/Q feedback_divider_i._264_/A
+ feedback_divider_i._564_/Q VDD VSS sg13cmos5l_a21oi_1
XFILLER_22_113 VDD VSS sg13cmos5l_decap_4
XFILLER_26_87 VDD VSS sg13cmos5l_fill_1
XFILLER_3_14 VDD VSS sg13cmos5l_decap_8
XFILLER_3_25 VDD VSS sg13cmos5l_fill_2
XFILLER_8_194 VDD VSS sg13cmos5l_decap_8
Xfeedback_divider_i._278_ feedback_divider_i._278_/Y feedback_divider_i._278_/A VDD
+ VSS sg13cmos5l_inv_2
Xfeedback_divider_i._347_ feedback_divider_i._347_/Y feedback_divider_i._574_/Q feedback_divider_i._586_/Q
+ feedback_divider_i._585_/Q feedback_divider_i._573_/Q VDD VSS sg13cmos5l_a22oi_1
Xfeedback_divider_i._416_ feedback_divider_i._416_/Y feedback_divider_i._498_/Q feedback_divider_i._290_/A
+ feedback_divider_i._538_/Q VDD VSS sg13cmos5l_a21oi_1
Xfeedback_divider_i.configuration_decode_i._070_ feedback_divider_i._259_/A feedback_divider_i.configuration_decode_i._066_/Y
+ fanout63/X feedback_divider_i.configuration_decode_i._044_/A feedback_divider_i.configuration_decode_i._049_/Y
+ VDD VSS sg13cmos5l_a22oi_1
XFILLER_24_219 VDD VSS sg13cmos5l_decap_8
XFILLER_2_145 VDD VSS sg13cmos5l_fill_1
XFILLER_9_35 VDD VSS sg13cmos5l_fill_1
Xfeedback_divider_i.configuration_decode_i._122_ fanout15/A input9/X input10/X VDD
+ VSS sg13cmos5l_nand2b_1
Xfeedback_divider_i.configuration_decode_i._053_ feedback_divider_i._249_/A feedback_divider_i.configuration_decode_i._072_/C
+ feedback_divider_i.configuration_decode_i._051_/Y feedback_divider_i.configuration_decode_i._047_/Y
+ fanout62/X VDD VSS sg13cmos5l_a22oi_1
XFILLER_11_222 VDD VSS sg13cmos5l_fill_1
XFILLER_7_215 VDD VSS sg13cmos5l_fill_2
Xclkbuf_regs_2_div8 clkbuf_regs_2_div8/X clkbuf_regs_2_div8/A VDD VSS sg13cmos5l_buf_16
Xfeedback_divider_i.configuration_decode_i._105_ feedback_divider_i._277_/A input5/X
+ fanout16/X input6/X feedback_divider_i.configuration_decode_i._141_/D VDD VSS sg13cmos5l_nor4_1
XFILLER_1_0 VDD VSS sg13cmos5l_decap_8
Xfeedback_divider_i._595_ feedback_divider_i._595_/Q clkbuf_4_6_0_pll_clk_regs/X feedback_divider_i._595_/D
+ fanout25/X VDD VSS sg13cmos5l_dfrbpq_2
XFILLER_4_229 VDD VSS sg13cmos5l_decap_8
XFILLER_28_163 VDD VSS sg13cmos5l_decap_4
XFILLER_3_240 VDD VSS sg13cmos5l_decap_4
XFILLER_3_262 VDD VSS sg13cmos5l_decap_8
XFILLER_6_14 VDD VSS sg13cmos5l_fill_2
Xfeedback_divider_i._380_ feedback_divider_i._380_/Y feedback_divider_i._502_/Q feedback_divider_i._272_/A
+ feedback_divider_i._556_/Q VDD VSS sg13cmos5l_a21oi_1
XFILLER_19_152 VDD VSS sg13cmos5l_decap_8
Xclkbuf_4_1_0_pll_clk_regs clkbuf_4_1_0_pll_clk_regs/X clkbuf_4_1_0_pll_clk_regs/A
+ VDD VSS sg13cmos5l_buf_8
Xfeedback_divider_i._578_ feedback_divider_i._578_/Q clkbuf_4_4_0_pll_clk_regs/X feedback_divider_i._578_/D
+ fanout24/X VDD VSS sg13cmos5l_dfrbpq_2
XFILLER_0_265 VDD VSS sg13cmos5l_fill_1
XFILLER_16_100 VDD VSS sg13cmos5l_fill_2
XFILLER_16_122 VDD VSS sg13cmos5l_fill_2
XFILLER_16_155 VDD VSS sg13cmos5l_fill_2
Xfeedback_divider_i._294_ feedback_divider_i._294_/Y feedback_divider_i._294_/A VDD
+ VSS sg13cmos5l_inv_2
Xfeedback_divider_i._501_ feedback_divider_i._501_/Q clkbuf_4_4_0_pll_clk_regs/X feedback_divider_i._503_/D
+ fanout24/X VDD VSS sg13cmos5l_dfrbpq_2
Xfeedback_divider_i._432_ feedback_divider_i._432_/Y feedback_divider_i._496_/Q feedback_divider_i._298_/A
+ feedback_divider_i._530_/Q VDD VSS sg13cmos5l_a21oi_1
Xfeedback_divider_i._363_ feedback_divider_i._566_/D feedback_divider_i._503_/Q feedback_divider_i._264_/Y
+ feedback_divider_i._362_/Y VDD VSS sg13cmos5l_o21ai_1
Xclkbuf_3_7_0_pll_clk_regs clkbuf_3_7_0_pll_clk_regs/X clkbuf_3_7_0_pll_clk_regs/A
+ VDD VSS sg13cmos5l_buf_8
XFILLER_26_44 VDD VSS sg13cmos5l_fill_2
XFILLER_9_118 VDD VSS sg13cmos5l_fill_1
Xfeedback_divider_i._277_ feedback_divider_i._277_/Y feedback_divider_i._277_/A VDD
+ VSS sg13cmos5l_inv_2
Xfeedback_divider_i._346_ feedback_divider_i._587_/D feedback_divider_i._572_/Q feedback_divider_i._255_/Y
+ feedback_divider_i._345_/Y VDD VSS sg13cmos5l_o21ai_1
Xfeedback_divider_i._415_ feedback_divider_i._540_/D feedback_divider_i._497_/Q feedback_divider_i._290_/Y
+ feedback_divider_i._414_/Y VDD VSS sg13cmos5l_o21ai_1
XFILLER_12_68 VDD VSS sg13cmos5l_decap_8
XFILLER_5_7 VDD VSS sg13cmos5l_decap_8
XFILLER_5_132 VDD VSS sg13cmos5l_decap_8
XFILLER_5_187 VDD VSS sg13cmos5l_fill_2
Xfeedback_divider_i._329_ feedback_divider_i._329_/Y feedback_divider_i._595_/Q feedback_divider_i._580_/Q
+ feedback_divider_i._594_/Q feedback_divider_i._579_/Q VDD VSS sg13cmos5l_a22oi_1
XFILLER_23_67 VDD VSS sg13cmos5l_decap_8
XFILLER_23_78 VDD VSS sg13cmos5l_decap_8
XFILLER_2_157 VDD VSS sg13cmos5l_decap_4
XFILLER_2_168 VDD VSS sg13cmos5l_fill_2
Xfeedback_divider_i.configuration_decode_i._121_ feedback_divider_i.configuration_decode_i._137_/D
+ fanout41/X fanout61/X VDD VSS sg13cmos5l_nor2b_1
Xfeedback_divider_i.configuration_decode_i._052_ feedback_divider_i.configuration_decode_i._052_/Y
+ fanout20/X fanout58/X fanout57/X VDD VSS sg13cmos5l_a21oi_1
Xoutput_divider_i.div2_ff pll_clk output_divider_i.div2_ff/D output_divider_i.div2_ff/CLK
+ output_divider_i.div2_ff/D output_divider_i._4_/X VDD VSS sg13cmos5l_dfrbp_2
Xfeedback_divider_i.configuration_decode_i._104_ fanout17/A fanout61/X fanout41/X
+ VDD VSS sg13cmos5l_nand2b_1
Xfeedback_divider_i._594_ feedback_divider_i._594_/Q clkbuf_4_6_0_pll_clk_regs/X feedback_divider_i._594_/D
+ fanout25/X VDD VSS sg13cmos5l_dfrbpq_2
XFILLER_1_92 VDD VSS sg13cmos5l_decap_4
XFILLER_27_0 VDD VSS sg13cmos5l_decap_8
Xoutput_divider_i.vco_input_buffer.output_inverter_73 output_divider_i.div2_ff/CLK
+ output_divider_i.vco_input_buffer.input_inverter_72/Y VDD VSS sg13cmos5l_inv_16
Xfeedback_divider_i._577_ feedback_divider_i._577_/Q clkbuf_4_6_0_pll_clk_regs/X feedback_divider_i._580_/D
+ fanout27/X VDD VSS sg13cmos5l_dfrbpq_2
XFILLER_0_244 VDD VSS sg13cmos5l_fill_2
XFILLER_25_123 VDD VSS sg13cmos5l_fill_1
XFILLER_25_189 VDD VSS sg13cmos5l_fill_2
Xfeedback_divider_i._500_ feedback_divider_i._500_/Q feedback_divider_i._561_/CLK
+ feedback_divider_i._504_/D fanout35/X VDD VSS sg13cmos5l_dfrbpq_2
Xfeedback_divider_i._431_ feedback_divider_i._532_/D feedback_divider_i._495_/Q feedback_divider_i._298_/Y
+ feedback_divider_i._430_/Y VDD VSS sg13cmos5l_o21ai_1
XFILLER_16_189 VDD VSS sg13cmos5l_decap_8
Xfeedback_divider_i._293_ feedback_divider_i._293_/Y feedback_divider_i._293_/A VDD
+ VSS sg13cmos5l_inv_2
Xfeedback_divider_i._362_ feedback_divider_i._362_/Y feedback_divider_i._504_/Q feedback_divider_i._263_/A
+ feedback_divider_i._565_/Q VDD VSS sg13cmos5l_a21oi_1
XFILLER_13_115 VDD VSS sg13cmos5l_decap_4
XFILLER_26_78 VDD VSS sg13cmos5l_fill_2
XFILLER_21_170 VDD VSS sg13cmos5l_decap_4
Xfeedback_divider_i._276_ feedback_divider_i._276_/Y feedback_divider_i._276_/A VDD
+ VSS sg13cmos5l_inv_2
Xfeedback_divider_i._345_ feedback_divider_i._345_/Y feedback_divider_i._587_/Q feedback_divider_i._574_/Q
+ feedback_divider_i._586_/Q feedback_divider_i._573_/Q VDD VSS sg13cmos5l_a22oi_1
Xfeedback_divider_i._414_ feedback_divider_i._414_/Y feedback_divider_i._498_/Q feedback_divider_i._289_/A
+ feedback_divider_i._539_/Q VDD VSS sg13cmos5l_a21oi_1
XFILLER_12_181 VDD VSS sg13cmos5l_fill_1
XFILLER_8_163 VDD VSS sg13cmos5l_decap_8
Xclkbuf_0_pll_clk clkbuf_0_pll_clk/X pll_clk VDD VSS sg13cmos5l_buf_16
XFILLER_18_207 VDD VSS sg13cmos5l_fill_1
XFILLER_5_111 VDD VSS sg13cmos5l_decap_8
XFILLER_17_262 VDD VSS sg13cmos5l_decap_8
Xfeedback_divider_i._259_ feedback_divider_i._259_/Y feedback_divider_i._259_/A VDD
+ VSS sg13cmos5l_inv_2
Xfeedback_divider_i._328_ feedback_divider_i._596_/D feedback_divider_i._578_/Q feedback_divider_i._246_/Y
+ feedback_divider_i._327_/Y VDD VSS sg13cmos5l_o21ai_1
XFILLER_23_46 VDD VSS sg13cmos5l_decap_8
XFILLER_2_125 VDD VSS sg13cmos5l_fill_1
XFILLER_4_92 VDD VSS sg13cmos5l_decap_8
Xfeedback_divider_i.configuration_decode_i._120_ feedback_divider_i._292_/A feedback_divider_i.configuration_decode_i._156_/A
+ fanout16/X VDD VSS sg13cmos5l_nor2_1
Xfeedback_divider_i.configuration_decode_i._051_ feedback_divider_i.configuration_decode_i._051_/Y
+ fanout20/X fanout58/X VDD VSS sg13cmos5l_nand2_1
XFILLER_0_28 VDD VSS sg13cmos5l_decap_8
XFILLER_14_287 VDD VSS sg13cmos5l_decap_8
XFILLER_18_57 VDD VSS sg13cmos5l_fill_1
XFILLER_11_202 VDD VSS sg13cmos5l_fill_2
Xclkload0 clkload0/X clkload0/A VDD VSS sg13cmos5l_buf_2
Xfeedback_divider_i.configuration_decode_i._103_ feedback_divider_i.configuration_decode_i._119_/D
+ fanout60/X fanout40/X VDD VSS sg13cmos5l_nor2b_1
Xfeedback_divider_i._593_ feedback_divider_i._593_/Q clkbuf_4_5_0_pll_clk_regs/X feedback_divider_i._593_/D
+ fanout26/X VDD VSS sg13cmos5l_dfrbpq_2
XFILLER_6_261 VDD VSS sg13cmos5l_decap_8
XFILLER_6_272 VDD VSS sg13cmos5l_fill_1
XFILLER_28_187 VDD VSS sg13cmos5l_fill_2
XFILLER_13_7 VDD VSS sg13cmos5l_decap_8
XFILLER_19_110 VDD VSS sg13cmos5l_decap_4
XFILLER_6_49 VDD VSS sg13cmos5l_fill_1
Xfeedback_divider_i._576_ feedback_divider_i._576_/Q clkbuf_4_6_0_pll_clk_regs/X feedback_divider_i._579_/D
+ fanout27/X VDD VSS sg13cmos5l_dfrbpq_2
XFILLER_13_308 VDD VSS sg13cmos5l_fill_1
XFILLER_15_58 VDD VSS sg13cmos5l_decap_4
XFILLER_25_146 VDD VSS sg13cmos5l_decap_8
Xclkbuf_0_output_divider_i.div8_clk clkbuf_0_output_divider_i.div8_clk/X clkbuf_regs_2_div8/A
+ VDD VSS sg13cmos5l_buf_16
Xclkbuf_1_0_0_pll_clk_regs clkbuf_2_1_0_pll_clk_regs/A clkbuf_0_pll_clk_regs/X VDD
+ VSS sg13cmos5l_buf_8
Xoutput_divider_i.div8_ff clkbuf_regs_2_div8/A output_divider_i.div8_ff/D output_divider_i.div8_ff/CLK
+ output_divider_i.div8_ff/D output_divider_i._4_/X VDD VSS sg13cmos5l_dfrbp_2
XFILLER_0_223 VDD VSS sg13cmos5l_decap_8
XFILLER_8_301 VDD VSS sg13cmos5l_decap_8
Xfeedback_divider_i._292_ feedback_divider_i._292_/Y feedback_divider_i._292_/A VDD
+ VSS sg13cmos5l_inv_2
Xfeedback_divider_i._430_ feedback_divider_i._430_/Y feedback_divider_i._496_/Q feedback_divider_i._297_/A
+ feedback_divider_i._531_/Q VDD VSS sg13cmos5l_a21oi_1
Xfeedback_divider_i._361_ feedback_divider_i._567_/D feedback_divider_i._503_/Q feedback_divider_i._263_/Y
+ feedback_divider_i._360_/Y VDD VSS sg13cmos5l_o21ai_1
Xfeedback_divider_i._559_ feedback_divider_i._559_/Q clkbuf_4_6_0_pll_clk_regs/X feedback_divider_i._559_/D
+ fanout27/X VDD VSS sg13cmos5l_dfrbpq_2
XFILLER_26_46 VDD VSS sg13cmos5l_fill_1
Xclkbuf_0_pll_clk_regs clkbuf_0_pll_clk_regs/X clkbuf_regs_0_half/X VDD VSS sg13cmos5l_buf_16
Xfeedback_divider_i._344_ feedback_divider_i._588_/D feedback_divider_i._572_/Q feedback_divider_i._254_/Y
+ feedback_divider_i._343_/Y VDD VSS sg13cmos5l_o21ai_1
Xfeedback_divider_i._413_ feedback_divider_i._541_/D feedback_divider_i._497_/Q feedback_divider_i._289_/Y
+ feedback_divider_i._412_/Y VDD VSS sg13cmos5l_o21ai_1
XFILLER_8_120 VDD VSS sg13cmos5l_fill_1
Xfeedback_divider_i._275_ feedback_divider_i._275_/Y feedback_divider_i._275_/A VDD
+ VSS sg13cmos5l_inv_2
XFILLER_12_48 VDD VSS sg13cmos5l_decap_8
XFILLER_26_230 VDD VSS sg13cmos5l_decap_4
Xclkbuf_3_3_0_pll_clk_regs clkbuf_4_7_0_pll_clk_regs/A clkbuf_3_3_0_pll_clk_regs/A
+ VDD VSS sg13cmos5l_buf_8
XFILLER_17_252 VDD VSS sg13cmos5l_decap_4
XFILLER_5_189 VDD VSS sg13cmos5l_fill_1
Xclkbuf_1_0_0_output_divider_i.div4_clk_regs output_divider_i.div8_ff/CLK clkbuf_0_output_divider_i.div4_clk_regs/X
+ VDD VSS sg13cmos5l_buf_8
Xfeedback_divider_i._258_ feedback_divider_i._258_/Y feedback_divider_i._258_/A VDD
+ VSS sg13cmos5l_inv_2
Xfeedback_divider_i._327_ feedback_divider_i._327_/Y feedback_divider_i._579_/Q feedback_divider_i._595_/Q
+ feedback_divider_i._580_/Q feedback_divider_i._596_/Q VDD VSS sg13cmos5l_a22oi_1
XFILLER_23_233 VDD VSS sg13cmos5l_fill_2
Xfeedback_divider_i.configuration_decode_i._050_ feedback_divider_i._248_/A feedback_divider_i.configuration_decode_i._041_/Y
+ fanout20/X feedback_divider_i.configuration_decode_i._044_/A feedback_divider_i.configuration_decode_i._049_/Y
+ VDD VSS sg13cmos5l_a22oi_1
XFILLER_14_266 VDD VSS sg13cmos5l_decap_8
XFILLER_9_49 VDD VSS sg13cmos5l_decap_8
XFILLER_20_203 VDD VSS sg13cmos5l_fill_1
XFILLER_20_236 VDD VSS sg13cmos5l_fill_1
XFILLER_20_247 VDD VSS sg13cmos5l_fill_2
XFILLER_9_281 VDD VSS sg13cmos5l_fill_2
Xclkload1 clkload1/X clkload1/A VDD VSS sg13cmos5l_buf_2
Xfeedback_divider_i.configuration_decode_i._102_ feedback_divider_i._276_/A fanout60/X
+ fanout40/X feedback_divider_i.configuration_decode_i._156_/A VDD VSS sg13cmos5l_nor3_1
Xfeedback_divider_i._592_ feedback_divider_i._592_/Q clkload0/A feedback_divider_i._592_/D
+ fanout28/X VDD VSS sg13cmos5l_dfrbpq_2
XFILLER_10_280 VDD VSS sg13cmos5l_fill_1
XFILLER_28_100 VDD VSS sg13cmos5l_decap_8
XFILLER_28_133 VDD VSS sg13cmos5l_decap_4
XFILLER_28_199 VDD VSS sg13cmos5l_decap_8
Xfeedback_divider_i._575_ feedback_divider_i._575_/Q clkload0/A feedback_divider_i._575_/D
+ fanout27/X VDD VSS sg13cmos5l_dfrbpq_2
XFILLER_16_147 VDD VSS sg13cmos5l_fill_2
Xfeedback_divider_i._291_ feedback_divider_i._291_/Y feedback_divider_i._291_/A VDD
+ VSS sg13cmos5l_inv_2
Xfeedback_divider_i._360_ feedback_divider_i._360_/Y feedback_divider_i._262_/A feedback_divider_i._504_/Q
+ feedback_divider_i._566_/Q VDD VSS sg13cmos5l_a21oi_1
XFILLER_22_106 VDD VSS sg13cmos5l_decap_8
XFILLER_22_117 VDD VSS sg13cmos5l_fill_1
Xfeedback_divider_i._558_ feedback_divider_i._558_/Q clkbuf_4_6_0_pll_clk_regs/X feedback_divider_i._558_/D
+ fanout27/X VDD VSS sg13cmos5l_dfrbpq_2
Xfeedback_divider_i._489_ feedback_divider_i._489_/Q clkbuf_4_1_0_pll_clk_regs/X feedback_divider_i._503_/D
+ fanout21/X VDD VSS sg13cmos5l_dfrbpq_2
Xfeedback_divider_i._412_ feedback_divider_i._412_/Y feedback_divider_i._498_/Q feedback_divider_i._288_/A
+ feedback_divider_i._540_/Q VDD VSS sg13cmos5l_a21oi_1
XFILLER_12_194 VDD VSS sg13cmos5l_decap_8
XFILLER_8_143 VDD VSS sg13cmos5l_decap_4
XFILLER_8_187 VDD VSS sg13cmos5l_decap_8
Xfeedback_divider_i._274_ feedback_divider_i._274_/Y feedback_divider_i._274_/A VDD
+ VSS sg13cmos5l_inv_2
Xfeedback_divider_i._343_ feedback_divider_i._343_/Y feedback_divider_i._573_/Q feedback_divider_i._587_/Q
+ feedback_divider_i._574_/Q feedback_divider_i._588_/Q VDD VSS sg13cmos5l_a22oi_1
Xfeedback_divider_i._257_ feedback_divider_i._257_/Y feedback_divider_i._257_/A VDD
+ VSS sg13cmos5l_inv_2
Xfeedback_divider_i._326_ feedback_divider_i._580_/D feedback_divider_i._579_/D VDD
+ VSS sg13cmos5l_inv_2
XFILLER_13_92 VDD VSS sg13cmos5l_decap_4
XFILLER_2_138 VDD VSS sg13cmos5l_decap_8
XFILLER_3_7 VDD VSS sg13cmos5l_decap_8
XFILLER_9_28 VDD VSS sg13cmos5l_decap_8
Xfanout60 fanout60/X fanout61/X VDD VSS sg13cmos5l_buf_1
Xfeedback_divider_i._309_ feedback_divider_i._309_/Y feedback_divider_i._309_/A VDD
+ VSS sg13cmos5l_inv_2
Xfeedback_divider_i.configuration_decode_i._101_ feedback_divider_i.configuration_decode_i._156_/A
+ fanout55/X fanout53/X fanout42/X fanout48/X VDD VSS sg13cmos5l_nand4_1
Xfeedback_divider_i._591_ feedback_divider_i._591_/Q clkload0/A feedback_divider_i._591_/D
+ fanout28/X VDD VSS sg13cmos5l_dfrbpq_2
XFILLER_19_304 VDD VSS sg13cmos5l_decap_4
XFILLER_24_91 VDD VSS sg13cmos5l_decap_8
XFILLER_6_241 VDD VSS sg13cmos5l_decap_8
XFILLER_1_51 VDD VSS sg13cmos5l_decap_4
XFILLER_28_112 VDD VSS sg13cmos5l_fill_2
XFILLER_28_145 VDD VSS sg13cmos5l_decap_8
XFILLER_28_156 VDD VSS sg13cmos5l_decap_8
XFILLER_19_145 VDD VSS sg13cmos5l_decap_8
XFILLER_19_167 VDD VSS sg13cmos5l_fill_1
XFILLER_19_178 VDD VSS sg13cmos5l_fill_1
XFILLER_28_178 VDD VSS sg13cmos5l_fill_1
XFILLER_28_189 VDD VSS sg13cmos5l_fill_1
XFILLER_3_233 VDD VSS sg13cmos5l_decap_8
XFILLER_3_255 VDD VSS sg13cmos5l_decap_8
Xfeedback_divider_i._574_ feedback_divider_i._574_/Q feedback_divider_i._588_/CLK
+ feedback_divider_i._580_/D fanout36/X VDD VSS sg13cmos5l_dfrbpq_2
XFILLER_25_0 VDD VSS sg13cmos5l_fill_1
XFILLER_0_258 VDD VSS sg13cmos5l_decap_8
Xfeedback_divider_i._290_ feedback_divider_i._290_/Y feedback_divider_i._290_/A VDD
+ VSS sg13cmos5l_inv_2
XFILLER_15_192 VDD VSS sg13cmos5l_decap_8
XFILLER_7_50 VDD VSS sg13cmos5l_decap_4
Xfeedback_divider_i._557_ feedback_divider_i._557_/Q clkbuf_4_3_0_pll_clk_regs/X feedback_divider_i._557_/D
+ fanout25/X VDD VSS sg13cmos5l_dfrbpq_2
Xfeedback_divider_i._488_ feedback_divider_i._504_/D feedback_divider_i._596_/Q feedback_divider_i._579_/D
+ VDD VSS sg13cmos5l_and2_2
XFILLER_21_184 VDD VSS sg13cmos5l_fill_2
XFILLER_26_37 VDD VSS sg13cmos5l_decap_8
XFILLER_8_177 VDD VSS sg13cmos5l_decap_4
Xfeedback_divider_i._273_ feedback_divider_i._273_/Y feedback_divider_i._273_/A VDD
+ VSS sg13cmos5l_inv_2
Xfeedback_divider_i._342_ feedback_divider_i._589_/D feedback_divider_i._575_/Q feedback_divider_i._253_/Y
+ feedback_divider_i._341_/Y VDD VSS sg13cmos5l_o21ai_1
Xfeedback_divider_i._411_ feedback_divider_i._542_/D feedback_divider_i._497_/Q feedback_divider_i._288_/Y
+ feedback_divider_i._410_/Y VDD VSS sg13cmos5l_o21ai_1
XFILLER_5_125 VDD VSS sg13cmos5l_decap_8
Xfeedback_divider_i._325_ feedback_divider_i._325_/Y feedback_divider_i._325_/A VDD
+ VSS sg13cmos5l_inv_2
Xfeedback_divider_i._256_ feedback_divider_i._256_/Y feedback_divider_i._256_/A VDD
+ VSS sg13cmos5l_inv_2
XFILLER_14_202 VDD VSS sg13cmos5l_fill_2
XFILLER_2_106 VDD VSS sg13cmos5l_decap_4
XFILLER_13_71 VDD VSS sg13cmos5l_decap_8
Xfanout50 fanout50/X input7/X VDD VSS sg13cmos5l_buf_1
Xfanout61 fanout61/X input10/X VDD VSS sg13cmos5l_buf_1
Xfeedback_divider_i._308_ feedback_divider_i._308_/Y feedback_divider_i._308_/A VDD
+ VSS sg13cmos5l_inv_2
XFILLER_11_249 VDD VSS sg13cmos5l_decap_4
XFILLER_9_283 VDD VSS sg13cmos5l_fill_1
XFILLER_9_294 VDD VSS sg13cmos5l_decap_8
Xfeedback_divider_i.configuration_decode_i._100_ feedback_divider_i._275_/A fanout42/X
+ fanout48/X feedback_divider_i.configuration_decode_i._100_/C feedback_divider_i.configuration_decode_i._155_/C
+ VDD VSS sg13cmos5l_and4_1
XFILLER_24_70 VDD VSS sg13cmos5l_decap_8
Xfeedback_divider_i._325__65 feedback_divider_i._325_/A VDD VSS sg13cmos5l_tielo
Xfeedback_divider_i._590_ feedback_divider_i._590_/Q clkload0/A feedback_divider_i._590_/D
+ fanout28/X VDD VSS sg13cmos5l_dfrbpq_2
XFILLER_1_85 VDD VSS sg13cmos5l_decap_8
XFILLER_10_83 VDD VSS sg13cmos5l_decap_8
XFILLER_16_308 VDD VSS sg13cmos5l_fill_1
Xfeedback_divider_i._573_ feedback_divider_i._573_/Q feedback_divider_i._588_/CLK
+ feedback_divider_i._579_/D fanout36/X VDD VSS sg13cmos5l_dfrbpq_2
XFILLER_18_0 VDD VSS sg13cmos5l_decap_4
XFILLER_0_237 VDD VSS sg13cmos5l_decap_8
XFILLER_16_116 VDD VSS sg13cmos5l_fill_2
XFILLER_16_149 VDD VSS sg13cmos5l_fill_1
Xclkbuf_4_8_0_pll_clk_regs clkbuf_4_8_0_pll_clk_regs/X clkbuf_4_9_0_pll_clk_regs/A
+ VDD VSS sg13cmos5l_buf_8
Xfeedback_divider_i._556_ feedback_divider_i._556_/Q clkbuf_4_1_0_pll_clk_regs/X feedback_divider_i._556_/D
+ fanout24/X VDD VSS sg13cmos5l_dfrbpq_2
Xfeedback_divider_i._487_ fanout39/A _1_/A enable VDD VSS sg13cmos5l_and2_1
XFILLER_13_119 VDD VSS sg13cmos5l_fill_2
XFILLER_21_163 VDD VSS sg13cmos5l_decap_8
XFILLER_16_60 VDD VSS sg13cmos5l_decap_4
XFILLER_8_134 VDD VSS sg13cmos5l_decap_4
XFILLER_8_156 VDD VSS sg13cmos5l_decap_8
Xfeedback_divider_i._272_ feedback_divider_i._272_/Y feedback_divider_i._272_/A VDD
+ VSS sg13cmos5l_inv_2
Xfeedback_divider_i._341_ feedback_divider_i._341_/Y feedback_divider_i._577_/Q feedback_divider_i._589_/Q
+ feedback_divider_i._588_/Q feedback_divider_i._576_/Q VDD VSS sg13cmos5l_a22oi_1
Xfeedback_divider_i._410_ feedback_divider_i._410_/Y feedback_divider_i._498_/Q feedback_divider_i._287_/A
+ feedback_divider_i._541_/Q VDD VSS sg13cmos5l_a21oi_1
Xfeedback_divider_i._539_ feedback_divider_i._539_/Q clkbuf_4_9_0_pll_clk_regs/X feedback_divider_i._539_/D
+ fanout31/X VDD VSS sg13cmos5l_dfrbpq_2
XFILLER_4_85 VDD VSS sg13cmos5l_decap_8
Xfeedback_divider_i._255_ feedback_divider_i._255_/Y feedback_divider_i._255_/A VDD
+ VSS sg13cmos5l_inv_2
Xfeedback_divider_i._324_ feedback_divider_i._324_/Y feedback_divider_i._484_/B VDD
+ VSS sg13cmos5l_inv_2
XFILLER_23_39 VDD VSS sg13cmos5l_decap_8
Xfanout40 fanout40/X fanout41/X VDD VSS sg13cmos5l_buf_1
Xfanout51 fanout51/X input7/X VDD VSS sg13cmos5l_buf_1
Xfanout62 fanout62/X input1/X VDD VSS sg13cmos5l_buf_1
Xfeedback_divider_i._307_ feedback_divider_i._307_/Y feedback_divider_i._307_/A VDD
+ VSS sg13cmos5l_inv_2
XFILLER_11_239 VDD VSS sg13cmos5l_decap_4
XFILLER_9_251 VDD VSS sg13cmos5l_fill_2
XFILLER_6_254 VDD VSS sg13cmos5l_fill_1
XFILLER_10_73 VDD VSS sg13cmos5l_decap_4
XFILLER_28_114 VDD VSS sg13cmos5l_fill_1
XFILLER_19_114 VDD VSS sg13cmos5l_fill_1
XFILLER_3_279 VDD VSS sg13cmos5l_fill_2
Xfeedback_divider_i._572_ feedback_divider_i._572_/Q clkload0/A feedback_divider_i._572_/D
+ fanout27/X VDD VSS sg13cmos5l_dfrbpq_2
XFILLER_25_139 VDD VSS sg13cmos5l_decap_8
XFILLER_16_128 VDD VSS sg13cmos5l_decap_4
XFILLER_21_50 VDD VSS sg13cmos5l_fill_1
XFILLER_21_83 VDD VSS sg13cmos5l_decap_8
Xfeedback_divider_i._555_ feedback_divider_i._555_/Q clkbuf_4_1_0_pll_clk_regs/X feedback_divider_i._555_/D
+ fanout24/X VDD VSS sg13cmos5l_dfrbpq_2
Xfeedback_divider_i._486_ feedback_divider_i._503_/D feedback_divider_i._596_/Q feedback_divider_i._579_/D
+ VDD VSS sg13cmos5l_nand2b_2
XFILLER_21_142 VDD VSS sg13cmos5l_decap_8
XFILLER_21_186 VDD VSS sg13cmos5l_fill_1
XFILLER_5_308 VDD VSS sg13cmos5l_fill_1
Xfeedback_divider_i._271_ feedback_divider_i._271_/Y feedback_divider_i._271_/A VDD
+ VSS sg13cmos5l_inv_2
Xfeedback_divider_i._340_ feedback_divider_i._590_/D feedback_divider_i._575_/Q feedback_divider_i._252_/Y
+ feedback_divider_i._339_/Y VDD VSS sg13cmos5l_o21ai_1
Xclkbuf_1_0_0_pll_clk clkbuf_1_0_0_pll_clk/X clkbuf_0_pll_clk/X VDD VSS sg13cmos5l_buf_8
Xfeedback_divider_i._538_ feedback_divider_i._538_/Q feedback_divider_i._597_/CLK
+ feedback_divider_i._538_/D fanout33/X VDD VSS sg13cmos5l_dfrbpq_2
Xfeedback_divider_i._469_ feedback_divider_i._513_/D feedback_divider_i._491_/Q feedback_divider_i._317_/Y
+ feedback_divider_i._468_/Y VDD VSS sg13cmos5l_o21ai_1
XFILLER_17_223 VDD VSS sg13cmos5l_fill_1
XFILLER_17_256 VDD VSS sg13cmos5l_fill_1
XFILLER_17_278 VDD VSS sg13cmos5l_fill_2
XFILLER_4_182 VDD VSS sg13cmos5l_decap_8
Xfeedback_divider_i._254_ feedback_divider_i._254_/Y feedback_divider_i._254_/A VDD
+ VSS sg13cmos5l_inv_2
Xfeedback_divider_i._323_ feedback_divider_i._323_/Y feedback_divider_i._323_/A VDD
+ VSS sg13cmos5l_inv_2
XFILLER_2_119 VDD VSS sg13cmos5l_fill_1
XFILLER_4_64 VDD VSS sg13cmos5l_decap_4
XFILLER_13_51 VDD VSS sg13cmos5l_fill_2
XFILLER_8_0 VDD VSS sg13cmos5l_decap_4
Xfanout30 fanout30/X fanout34/X VDD VSS sg13cmos5l_buf_1
Xfanout41 fanout41/X input9/X VDD VSS sg13cmos5l_buf_1
Xfanout52 fanout52/X input7/X VDD VSS sg13cmos5l_buf_1
Xfanout63 fanout63/X input1/X VDD VSS sg13cmos5l_buf_1
XFILLER_28_307 VDD VSS sg13cmos5l_fill_2
Xfeedback_divider_i._306_ feedback_divider_i._306_/Y feedback_divider_i._306_/A VDD
+ VSS sg13cmos5l_inv_2
XFILLER_1_7 VDD VSS sg13cmos5l_decap_8
XFILLER_1_21 VDD VSS sg13cmos5l_fill_2
Xclkbuf_1_0_0_output_divider_i.div8_clk output_divider_i._5_/A2 clkbuf_0_output_divider_i.div8_clk/X
+ VDD VSS sg13cmos5l_buf_8
Xclkbuf_regs_1_div4 clkbuf_regs_1_div4/X clkbuf_regs_1_div4/A VDD VSS sg13cmos5l_buf_16
Xfeedback_divider_i.configuration_decode_i._089_ feedback_divider_i._268_/A fanout61/X
+ fanout41/X feedback_divider_i.configuration_decode_i._148_/A fanout19/X VDD VSS
+ sg13cmos5l_nor4_1
Xoutput_divider_i.div16_ff output_divider_i._5_/A3 output_divider_i.div16_ff/D output_divider_i.div16_ff/CLK
+ output_divider_i.div16_ff/D output_divider_i._4_/X VDD VSS sg13cmos5l_dfrbp_2
XFILLER_28_126 VDD VSS sg13cmos5l_decap_8
XFILLER_3_269 VDD VSS sg13cmos5l_fill_1
Xclkbuf_2_1_0_pll_clk_regs clkbuf_3_3_0_pll_clk_regs/A clkbuf_2_1_0_pll_clk_regs/A
+ VDD VSS sg13cmos5l_buf_8
Xfeedback_divider_i._571_ feedback_divider_i._571_/Q clkbuf_4_5_0_pll_clk_regs/X feedback_divider_i._580_/D
+ fanout25/X VDD VSS sg13cmos5l_dfrbpq_2
XFILLER_25_107 VDD VSS sg13cmos5l_fill_2
XFILLER_24_162 VDD VSS sg13cmos5l_decap_8
Xfeedback_divider_i._554_ feedback_divider_i._554_/Q clkbuf_4_3_0_pll_clk_regs/X feedback_divider_i._554_/D
+ fanout39/X VDD VSS sg13cmos5l_dfrbpq_2
XFILLER_23_0 VDD VSS sg13cmos5l_decap_4
XFILLER_7_97 VDD VSS sg13cmos5l_decap_8
Xfeedback_divider_i._485_ feedback_divider_i._505_/D feedback_divider_i._489_/Q feedback_divider_i._325_/Y
+ feedback_divider_i._484_/Y VDD VSS sg13cmos5l_o21ai_1
Xfeedback_divider_i._270_ feedback_divider_i._270_/Y feedback_divider_i._270_/A VDD
+ VSS sg13cmos5l_inv_2
XFILLER_12_143 VDD VSS sg13cmos5l_fill_2
XFILLER_12_187 VDD VSS sg13cmos5l_decap_8
XFILLER_8_147 VDD VSS sg13cmos5l_fill_1
Xclkbuf_4_4_0_pll_clk_regs clkbuf_4_4_0_pll_clk_regs/X clkbuf_4_5_0_pll_clk_regs/A
+ VDD VSS sg13cmos5l_buf_8
Xfeedback_divider_i._537_ feedback_divider_i._537_/Q feedback_divider_i._597_/CLK
+ feedback_divider_i._537_/D fanout33/X VDD VSS sg13cmos5l_dfrbpq_2
Xfeedback_divider_i._468_ feedback_divider_i._468_/Y feedback_divider_i._492_/Q feedback_divider_i._316_/A
+ feedback_divider_i._512_/Q VDD VSS sg13cmos5l_a21oi_1
Xfeedback_divider_i._399_ feedback_divider_i._548_/D feedback_divider_i._499_/Q feedback_divider_i._282_/Y
+ feedback_divider_i._398_/Y VDD VSS sg13cmos5l_o21ai_1
XFILLER_7_180 VDD VSS sg13cmos5l_decap_4
XFILLER_5_139 VDD VSS sg13cmos5l_decap_4
Xfeedback_divider_i._253_ feedback_divider_i._253_/Y feedback_divider_i._253_/A VDD
+ VSS sg13cmos5l_inv_2
Xfeedback_divider_i._322_ feedback_divider_i._322_/Y feedback_divider_i._322_/A VDD
+ VSS sg13cmos5l_inv_2
XFILLER_4_172 VDD VSS sg13cmos5l_decap_4
XFILLER_4_21 VDD VSS sg13cmos5l_decap_8
XFILLER_13_30 VDD VSS sg13cmos5l_decap_8
XFILLER_13_85 VDD VSS sg13cmos5l_decap_8
Xfanout20 fanout20/X fanout20/A VDD VSS sg13cmos5l_buf_1
Xfanout31 fanout31/X fanout34/X VDD VSS sg13cmos5l_buf_1
Xfanout42 fanout42/X fanout43/X VDD VSS sg13cmos5l_buf_1
Xfanout53 fanout53/X fanout54/X VDD VSS sg13cmos5l_buf_1
Xfeedback_divider_i._305_ feedback_divider_i._305_/Y feedback_divider_i._305_/A VDD
+ VSS sg13cmos5l_inv_2
XFILLER_19_308 VDD VSS sg13cmos5l_fill_1
XFILLER_1_55 VDD VSS sg13cmos5l_fill_2
XFILLER_24_84 VDD VSS sg13cmos5l_decap_8
XFILLER_27_7 VDD VSS sg13cmos5l_decap_4
XFILLER_6_234 VDD VSS sg13cmos5l_decap_8
XFILLER_6_278 VDD VSS sg13cmos5l_fill_2
Xfeedback_divider_i._246__64 feedback_divider_i._246_/A VDD VSS sg13cmos5l_tielo
Xfeedback_divider_i.configuration_decode_i._088_ feedback_divider_i._267_/A fanout61/X
+ fanout41/X feedback_divider_i.configuration_decode_i._147_/A fanout18/X VDD VSS
+ sg13cmos5l_nor4_1
XFILLER_19_138 VDD VSS sg13cmos5l_fill_2
XFILLER_19_51 VDD VSS sg13cmos5l_decap_4
XFILLER_3_248 VDD VSS sg13cmos5l_decap_8
Xfeedback_divider_i._570_ feedback_divider_i._570_/Q clkbuf_4_4_0_pll_clk_regs/X feedback_divider_i._579_/D
+ fanout25/X VDD VSS sg13cmos5l_dfrbpq_2
XFILLER_18_182 VDD VSS sg13cmos5l_decap_8
XFILLER_25_119 VDD VSS sg13cmos5l_decap_4
XFILLER_2_281 VDD VSS sg13cmos5l_decap_8
XFILLER_7_43 VDD VSS sg13cmos5l_decap_8
XFILLER_7_54 VDD VSS sg13cmos5l_fill_1
Xclkbuf_4_12_0_pll_clk_regs feedback_divider_i._561_/CLK clkbuf_3_6_0_pll_clk_regs/X
+ VDD VSS sg13cmos5l_buf_8
Xfeedback_divider_i._553_ feedback_divider_i._553_/Q clkbuf_4_3_0_pll_clk_regs/X feedback_divider_i._553_/D
+ fanout27/X VDD VSS sg13cmos5l_dfrbpq_2
Xfeedback_divider_i._484_ feedback_divider_i._484_/Y feedback_divider_i._490_/Q feedback_divider_i._484_/B
+ VDD VSS sg13cmos5l_nand2_1
XFILLER_16_0 VDD VSS sg13cmos5l_decap_4
XFILLER_12_122 VDD VSS sg13cmos5l_decap_8
XFILLER_16_96 VDD VSS sg13cmos5l_decap_4
Xfeedback_divider_i._536_ feedback_divider_i._536_/Q feedback_divider_i._597_/CLK
+ feedback_divider_i._536_/D fanout33/X VDD VSS sg13cmos5l_dfrbpq_2
Xfeedback_divider_i._467_ feedback_divider_i._514_/D feedback_divider_i._491_/Q feedback_divider_i._316_/Y
+ feedback_divider_i._466_/Y VDD VSS sg13cmos5l_o21ai_1
Xfeedback_divider_i._398_ feedback_divider_i._398_/Y feedback_divider_i._500_/Q feedback_divider_i._281_/A
+ feedback_divider_i._547_/Q VDD VSS sg13cmos5l_a21oi_1
XFILLER_17_269 VDD VSS sg13cmos5l_fill_1
XFILLER_5_118 VDD VSS sg13cmos5l_decap_8
Xfeedback_divider_i._252_ feedback_divider_i._252_/Y feedback_divider_i._252_/A VDD
+ VSS sg13cmos5l_inv_2
Xfeedback_divider_i._321_ feedback_divider_i._321_/Y feedback_divider_i._321_/A VDD
+ VSS sg13cmos5l_inv_2
XFILLER_4_99 VDD VSS sg13cmos5l_fill_2
Xfeedback_divider_i._519_ feedback_divider_i._519_/Q clkbuf_4_2_0_pll_clk_regs/X feedback_divider_i._519_/D
+ fanout23/X VDD VSS sg13cmos5l_dfrbpq_2
XFILLER_13_53 VDD VSS sg13cmos5l_fill_1
XFILLER_13_64 VDD VSS sg13cmos5l_fill_2
Xfanout21 fanout21/X fanout22/X VDD VSS sg13cmos5l_buf_1
Xfanout32 fanout32/X fanout34/X VDD VSS sg13cmos5l_buf_1
Xfanout43 fanout43/X fanout44/X VDD VSS sg13cmos5l_buf_1
Xfanout54 fanout54/X input6/X VDD VSS sg13cmos5l_buf_1
XFILLER_13_294 VDD VSS sg13cmos5l_decap_8
Xfeedback_divider_i._304_ feedback_divider_i._304_/Y feedback_divider_i._304_/A VDD
+ VSS sg13cmos5l_inv_2
XFILLER_11_209 VDD VSS sg13cmos5l_decap_8
XFILLER_24_41 VDD VSS sg13cmos5l_decap_8
XFILLER_24_63 VDD VSS sg13cmos5l_decap_8
Xfeedback_divider_i.configuration_decode_i._087_ feedback_divider_i._266_/A fanout61/X
+ fanout41/X feedback_divider_i.configuration_decode_i._146_/A fanout18/X VDD VSS
+ sg13cmos5l_nor4_1
Xfeedback_divider_i.configuration_decode_i._156_ feedback_divider_i._484_/B feedback_divider_i.configuration_decode_i._156_/A
+ fanout13/X VDD VSS sg13cmos5l_nor2_1
XFILLER_10_65 VDD VSS sg13cmos5l_decap_4
XFILLER_3_227 VDD VSS sg13cmos5l_fill_1
Xfeedback_divider_i.configuration_decode_i._139_ feedback_divider_i.configuration_decode_i._155_/D
+ fanout60/X fanout40/X VDD VSS sg13cmos5l_and2_1
XFILLER_8_308 VDD VSS sg13cmos5l_fill_1
Xfeedback_divider_i._552_ feedback_divider_i._552_/Q feedback_divider_i._561_/CLK
+ feedback_divider_i._552_/D fanout35/X VDD VSS sg13cmos5l_dfrbpq_2
Xfeedback_divider_i._483_ feedback_divider_i._506_/D feedback_divider_i._489_/Q feedback_divider_i._324_/Y
+ feedback_divider_i._482_/Y VDD VSS sg13cmos5l_o21ai_1
XFILLER_21_156 VDD VSS sg13cmos5l_decap_8
XFILLER_12_145 VDD VSS sg13cmos5l_fill_1
XFILLER_16_53 VDD VSS sg13cmos5l_decap_8
XFILLER_8_127 VDD VSS sg13cmos5l_decap_8
Xfeedback_divider_i._535_ feedback_divider_i._535_/Q feedback_divider_i._535_/CLK
+ feedback_divider_i._535_/D fanout33/X VDD VSS sg13cmos5l_dfrbpq_2
Xfeedback_divider_i._466_ feedback_divider_i._466_/Y feedback_divider_i._492_/Q feedback_divider_i._315_/A
+ feedback_divider_i._513_/Q VDD VSS sg13cmos5l_a21oi_1
Xfeedback_divider_i._397_ feedback_divider_i._549_/D feedback_divider_i._499_/Q feedback_divider_i._281_/Y
+ feedback_divider_i._396_/Y VDD VSS sg13cmos5l_o21ai_1
XFILLER_1_303 VDD VSS sg13cmos5l_decap_4
Xfeedback_divider_i._251_ feedback_divider_i._251_/Y feedback_divider_i._251_/A VDD
+ VSS sg13cmos5l_inv_2
Xfeedback_divider_i._320_ feedback_divider_i._320_/Y feedback_divider_i._320_/A VDD
+ VSS sg13cmos5l_inv_2
XFILLER_4_196 VDD VSS sg13cmos5l_decap_8
XFILLER_4_78 VDD VSS sg13cmos5l_decap_8
Xfeedback_divider_i._518_ feedback_divider_i._518_/Q clkbuf_4_2_0_pll_clk_regs/X feedback_divider_i._518_/D
+ fanout23/X VDD VSS sg13cmos5l_dfrbpq_2
Xfeedback_divider_i._449_ feedback_divider_i._523_/D feedback_divider_i._493_/Q feedback_divider_i._307_/Y
+ feedback_divider_i._448_/Y VDD VSS sg13cmos5l_o21ai_1
Xclkbuf_4_0_0_pll_clk_regs clkbuf_4_0_0_pll_clk_regs/X clkbuf_4_1_0_pll_clk_regs/A
+ VDD VSS sg13cmos5l_buf_8
Xfanout22 fanout22/X fanout23/X VDD VSS sg13cmos5l_buf_1
Xfanout33 fanout33/X fanout34/X VDD VSS sg13cmos5l_buf_1
Xfanout44 fanout44/X input8/X VDD VSS sg13cmos5l_buf_1
Xfanout55 fanout55/X fanout56/X VDD VSS sg13cmos5l_buf_1
XFILLER_9_200 VDD VSS sg13cmos5l_fill_2
Xfeedback_divider_i._303_ feedback_divider_i._303_/Y feedback_divider_i._303_/A VDD
+ VSS sg13cmos5l_inv_2
Xclkbuf_3_6_0_pll_clk_regs clkbuf_3_6_0_pll_clk_regs/X clkbuf_3_7_0_pll_clk_regs/A
+ VDD VSS sg13cmos5l_buf_8
XFILLER_10_221 VDD VSS sg13cmos5l_fill_1
XFILLER_24_53 VDD VSS sg13cmos5l_decap_4
XFILLER_6_0 VDD VSS sg13cmos5l_decap_8
Xfeedback_divider_i.configuration_decode_i._155_ feedback_divider_i._323_/A fanout43/X
+ fanout47/X feedback_divider_i.configuration_decode_i._155_/C feedback_divider_i.configuration_decode_i._155_/D
+ VDD VSS sg13cmos5l_and4_1
Xfeedback_divider_i.configuration_decode_i._086_ feedback_divider_i._265_/A fanout56/X
+ fanout18/X fanout54/X feedback_divider_i.configuration_decode_i._086_/D VDD VSS
+ sg13cmos5l_nor4_1
XFILLER_10_33 VDD VSS sg13cmos5l_decap_4
XFILLER_10_77 VDD VSS sg13cmos5l_fill_2
XFILLER_28_107 VDD VSS sg13cmos5l_fill_1
Xinput1 input1/X div_ratio[0] VDD VSS sg13cmos5l_buf_1
Xfeedback_divider_i.configuration_decode_i._138_ feedback_divider_i._308_/A feedback_divider_i.configuration_decode_i._156_/A
+ fanout15/X VDD VSS sg13cmos5l_nor2_1
Xfeedback_divider_i.configuration_decode_i._069_ feedback_divider_i._258_/A feedback_divider_i.configuration_decode_i._072_/C
+ feedback_divider_i.configuration_decode_i._051_/Y feedback_divider_i.configuration_decode_i._047_/Y
+ fanout62/X feedback_divider_i.configuration_decode_i._068_/Y VDD VSS sg13cmos5l_a221oi_1
XFILLER_15_121 VDD VSS sg13cmos5l_decap_8
XFILLER_21_32 VDD VSS sg13cmos5l_fill_2
XFILLER_24_198 VDD VSS sg13cmos5l_decap_8
Xfeedback_divider_i._551_ feedback_divider_i._551_/Q feedback_divider_i._551_/CLK
+ feedback_divider_i._551_/D fanout37/X VDD VSS sg13cmos5l_dfrbpq_2
Xfeedback_divider_i._482_ feedback_divider_i._482_/Y feedback_divider_i._490_/Q feedback_divider_i._323_/A
+ feedback_divider_i._505_/Q VDD VSS sg13cmos5l_a21oi_1
XFILLER_21_135 VDD VSS sg13cmos5l_decap_8
XFILLER_12_179 VDD VSS sg13cmos5l_fill_2
XFILLER_16_32 VDD VSS sg13cmos5l_decap_8
Xclkbuf_0_output_divider_i.div4_clk clkbuf_0_output_divider_i.div4_clk/X clkbuf_regs_1_div4/A
+ VDD VSS sg13cmos5l_buf_16
Xfeedback_divider_i._534_ feedback_divider_i._534_/Q feedback_divider_i._535_/CLK
+ feedback_divider_i._534_/D fanout32/X VDD VSS sg13cmos5l_dfrbpq_2
Xfeedback_divider_i._465_ feedback_divider_i._515_/D feedback_divider_i._491_/Q feedback_divider_i._315_/Y
+ feedback_divider_i._464_/Y VDD VSS sg13cmos5l_o21ai_1
Xfeedback_divider_i._396_ feedback_divider_i._396_/Y feedback_divider_i._500_/Q feedback_divider_i._280_/A
+ feedback_divider_i._548_/Q VDD VSS sg13cmos5l_a21oi_1
XFILLER_21_0 VDD VSS sg13cmos5l_decap_4
XFILLER_17_216 VDD VSS sg13cmos5l_fill_2
XFILLER_27_97 VDD VSS sg13cmos5l_fill_2
XFILLER_4_131 VDD VSS sg13cmos5l_fill_1
XFILLER_4_57 VDD VSS sg13cmos5l_fill_2
Xfeedback_divider_i._250_ feedback_divider_i._250_/Y feedback_divider_i._250_/A VDD
+ VSS sg13cmos5l_inv_2
Xfeedback_divider_i._517_ feedback_divider_i._517_/Q clkbuf_4_2_0_pll_clk_regs/X feedback_divider_i._517_/D
+ fanout23/X VDD VSS sg13cmos5l_dfrbpq_2
Xfeedback_divider_i._448_ feedback_divider_i._448_/Y feedback_divider_i._494_/Q feedback_divider_i._306_/A
+ feedback_divider_i._522_/Q VDD VSS sg13cmos5l_a21oi_1
Xfeedback_divider_i._379_ feedback_divider_i._558_/D feedback_divider_i._501_/Q feedback_divider_i._272_/Y
+ feedback_divider_i._378_/Y VDD VSS sg13cmos5l_o21ai_1
XFILLER_13_44 VDD VSS sg13cmos5l_decap_8
XFILLER_13_66 VDD VSS sg13cmos5l_fill_1
Xfanout12 fanout12/X fanout13/A VDD VSS sg13cmos5l_buf_1
Xfanout23 fanout23/X fanout39/X VDD VSS sg13cmos5l_buf_1
Xfanout34 fanout34/X fanout39/X VDD VSS sg13cmos5l_buf_1
Xfanout45 fanout45/X input8/X VDD VSS sg13cmos5l_buf_1
Xfanout56 fanout56/X input5/X VDD VSS sg13cmos5l_buf_1
Xfeedback_divider_i._302_ feedback_divider_i._302_/Y feedback_divider_i._302_/A VDD
+ VSS sg13cmos5l_inv_2
XFILLER_24_98 VDD VSS sg13cmos5l_fill_2
XFILLER_6_226 VDD VSS sg13cmos5l_fill_1
XFILLER_1_14 VDD VSS sg13cmos5l_decap_8
Xfeedback_divider_i.configuration_decode_i._154_ feedback_divider_i._322_/A fanout43/X
+ fanout47/X feedback_divider_i.configuration_decode_i._154_/C feedback_divider_i.configuration_decode_i._155_/D
+ VDD VSS sg13cmos5l_and4_1
Xfeedback_divider_i.configuration_decode_i._085_ fanout19/A fanout44/X fanout50/X
+ VDD VSS sg13cmos5l_nand2b_1
XFILLER_28_119 VDD VSS sg13cmos5l_decap_8
Xinput2 input2/X div_ratio[1] VDD VSS sg13cmos5l_buf_1
XFILLER_15_303 VDD VSS sg13cmos5l_decap_4
XFILLER_2_273 VDD VSS sg13cmos5l_fill_2
XFILLER_2_295 VDD VSS sg13cmos5l_decap_8
Xfeedback_divider_i.configuration_decode_i._137_ feedback_divider_i._307_/A fanout44/X
+ fanout49/X feedback_divider_i.configuration_decode_i._155_/C feedback_divider_i.configuration_decode_i._137_/D
+ VDD VSS sg13cmos5l_and4_1
Xfeedback_divider_i.configuration_decode_i._068_ feedback_divider_i.configuration_decode_i._068_/Y
+ fanout62/X fanout59/X VDD VSS sg13cmos5l_nor2_1
XFILLER_18_130 VDD VSS sg13cmos5l_fill_2
XFILLER_18_141 VDD VSS sg13cmos5l_decap_8
XFILLER_18_196 VDD VSS sg13cmos5l_decap_8
XFILLER_15_100 VDD VSS sg13cmos5l_fill_2
XFILLER_24_111 VDD VSS sg13cmos5l_decap_8
XFILLER_24_122 VDD VSS sg13cmos5l_fill_1
XFILLER_2_90 VDD VSS sg13cmos5l_fill_1
Xfeedback_divider_i._550_ feedback_divider_i._550_/Q feedback_divider_i._551_/CLK
+ feedback_divider_i._550_/D fanout35/X VDD VSS sg13cmos5l_dfrbpq_2
Xfeedback_divider_i._481_ feedback_divider_i._507_/D feedback_divider_i._489_/Q feedback_divider_i._323_/Y
+ feedback_divider_i._480_/Y VDD VSS sg13cmos5l_o21ai_1
XFILLER_15_199 VDD VSS sg13cmos5l_decap_8
XFILLER_12_136 VDD VSS sg13cmos5l_decap_8
XFILLER_11_191 VDD VSS sg13cmos5l_decap_8
Xfeedback_divider_i._533_ feedback_divider_i._533_/Q feedback_divider_i._535_/CLK
+ feedback_divider_i._533_/D fanout32/X VDD VSS sg13cmos5l_dfrbpq_2
Xfeedback_divider_i._464_ feedback_divider_i._464_/Y feedback_divider_i._492_/Q feedback_divider_i._314_/A
+ feedback_divider_i._514_/Q VDD VSS sg13cmos5l_a21oi_1
Xfeedback_divider_i._395_ feedback_divider_i._550_/D feedback_divider_i._499_/Q feedback_divider_i._280_/Y
+ feedback_divider_i._394_/Y VDD VSS sg13cmos5l_o21ai_1
XFILLER_14_0 VDD VSS sg13cmos5l_decap_8
XFILLER_7_173 VDD VSS sg13cmos5l_fill_2
XFILLER_7_184 VDD VSS sg13cmos5l_fill_1
XFILLER_27_43 VDD VSS sg13cmos5l_fill_1
XFILLER_4_14 VDD VSS sg13cmos5l_decap_8
XFILLER_4_165 VDD VSS sg13cmos5l_decap_8
XFILLER_4_176 VDD VSS sg13cmos5l_fill_2
Xfeedback_divider_i._516_ feedback_divider_i._516_/Q clkbuf_4_0_0_pll_clk_regs/X feedback_divider_i._516_/D
+ fanout22/X VDD VSS sg13cmos5l_dfrbpq_2
Xfeedback_divider_i._447_ feedback_divider_i._524_/D feedback_divider_i._493_/Q feedback_divider_i._306_/Y
+ feedback_divider_i._446_/Y VDD VSS sg13cmos5l_o21ai_1
Xfeedback_divider_i._378_ feedback_divider_i._378_/Y feedback_divider_i._502_/Q feedback_divider_i._271_/A
+ feedback_divider_i._557_/Q VDD VSS sg13cmos5l_a21oi_1
XFILLER_13_23 VDD VSS sg13cmos5l_decap_8
XFILLER_13_78 VDD VSS sg13cmos5l_fill_2
XFILLER_1_124 VDD VSS sg13cmos5l_fill_1
Xfanout13 fanout13/X fanout13/A VDD VSS sg13cmos5l_buf_1
Xfanout24 fanout24/X fanout25/X VDD VSS sg13cmos5l_buf_1
Xfanout35 fanout35/X fanout38/X VDD VSS sg13cmos5l_buf_1
Xfanout46 fanout46/X input8/X VDD VSS sg13cmos5l_buf_1
Xfanout57 fanout57/X input4/X VDD VSS sg13cmos5l_buf_1
Xfeedback_divider_i._301_ feedback_divider_i._301_/Y feedback_divider_i._301_/A VDD
+ VSS sg13cmos5l_inv_2
XFILLER_13_264 VDD VSS sg13cmos5l_fill_2
XFILLER_24_11 VDD VSS sg13cmos5l_decap_8
Xoutput_divider_i._5_ test_clk clkbuf_1_0_0_pll_clk/X output_divider_i._5_/A1 output_divider_i._5_/A2
+ output_divider_i._5_/A3 test_div_select[0] test_div_select[1] VDD VSS sg13cmos5l_mux4_1
XFILLER_10_278 VDD VSS sg13cmos5l_fill_2
XFILLER_24_77 VDD VSS sg13cmos5l_decap_8
Xfeedback_divider_i.configuration_decode_i._153_ feedback_divider_i._321_/A fanout43/X
+ fanout47/X feedback_divider_i.configuration_decode_i._153_/C feedback_divider_i.configuration_decode_i._155_/D
+ VDD VSS sg13cmos5l_and4_1
Xfeedback_divider_i.configuration_decode_i._084_ feedback_divider_i.configuration_decode_i._153_/C
+ fanout55/X fanout53/X VDD VSS sg13cmos5l_nor2_1
Xinput3 input3/X div_ratio[2] VDD VSS sg13cmos5l_buf_1
XFILLER_19_11 VDD VSS sg13cmos5l_decap_4
XFILLER_27_197 VDD VSS sg13cmos5l_decap_4
Xclkbuf_3_2_0_pll_clk_regs clkbuf_4_5_0_pll_clk_regs/A clkbuf_3_3_0_pll_clk_regs/A
+ VDD VSS sg13cmos5l_buf_8
Xfeedback_divider_i.configuration_decode_i._136_ feedback_divider_i._306_/A fanout44/X
+ fanout49/X feedback_divider_i.configuration_decode_i._154_/C feedback_divider_i.configuration_decode_i._137_/D
+ VDD VSS sg13cmos5l_and4_1
Xfeedback_divider_i.configuration_decode_i._067_ feedback_divider_i._257_/A feedback_divider_i.configuration_decode_i._066_/Y
+ fanout63/X feedback_divider_i.configuration_decode_i._054_/Y feedback_divider_i.configuration_decode_i._052_/Y
+ VDD VSS sg13cmos5l_a22oi_1
XFILLER_21_34 VDD VSS sg13cmos5l_fill_1
Xfeedback_divider_i._480_ feedback_divider_i._480_/Y feedback_divider_i._490_/Q feedback_divider_i._322_/A
+ feedback_divider_i._506_/Q VDD VSS sg13cmos5l_a21oi_1
Xfeedback_divider_i.configuration_decode_i._119_ feedback_divider_i._291_/A fanout43/X
+ fanout49/X feedback_divider_i.configuration_decode_i._155_/C feedback_divider_i.configuration_decode_i._119_/D
+ VDD VSS sg13cmos5l_and4_1
XFILLER_12_115 VDD VSS sg13cmos5l_decap_8
Xfeedback_divider_i._532_ feedback_divider_i._532_/Q feedback_divider_i._535_/CLK
+ feedback_divider_i._532_/D fanout32/X VDD VSS sg13cmos5l_dfrbpq_2
Xfeedback_divider_i._463_ feedback_divider_i._516_/D feedback_divider_i._491_/Q feedback_divider_i._314_/Y
+ feedback_divider_i._462_/Y VDD VSS sg13cmos5l_o21ai_1
Xfeedback_divider_i._394_ feedback_divider_i._394_/Y feedback_divider_i._500_/Q feedback_divider_i._279_/A
+ feedback_divider_i._549_/Q VDD VSS sg13cmos5l_a21oi_1
XFILLER_7_130 VDD VSS sg13cmos5l_fill_2
XFILLER_7_152 VDD VSS sg13cmos5l_decap_8
XFILLER_27_99 VDD VSS sg13cmos5l_fill_1
XFILLER_4_59 VDD VSS sg13cmos5l_fill_1
Xfeedback_divider_i._515_ feedback_divider_i._515_/Q clkbuf_4_0_0_pll_clk_regs/X feedback_divider_i._515_/D
+ fanout22/X VDD VSS sg13cmos5l_dfrbpq_2
Xfeedback_divider_i._446_ feedback_divider_i._446_/Y feedback_divider_i._494_/Q feedback_divider_i._305_/A
+ feedback_divider_i._523_/Q VDD VSS sg13cmos5l_a21oi_1
Xfeedback_divider_i._377_ feedback_divider_i._559_/D feedback_divider_i._501_/Q feedback_divider_i._271_/Y
+ feedback_divider_i._376_/Y VDD VSS sg13cmos5l_o21ai_1
Xfanout14 fanout14/X fanout15/X VDD VSS sg13cmos5l_buf_1
Xfanout25 fanout25/X fanout29/X VDD VSS sg13cmos5l_buf_1
Xfanout36 fanout36/X fanout38/X VDD VSS sg13cmos5l_buf_1
Xfanout47 fanout47/X fanout49/X VDD VSS sg13cmos5l_buf_1
Xfanout58 fanout58/X input3/X VDD VSS sg13cmos5l_buf_1
XFILLER_9_214 VDD VSS sg13cmos5l_fill_1
Xfeedback_divider_i._300_ feedback_divider_i._300_/Y feedback_divider_i._300_/A VDD
+ VSS sg13cmos5l_inv_2
Xfeedback_divider_i._429_ feedback_divider_i._533_/D feedback_divider_i._495_/Q feedback_divider_i._297_/Y
+ feedback_divider_i._428_/Y VDD VSS sg13cmos5l_o21ai_1
Xfeedback_divider_i.configuration_decode_i._152_ feedback_divider_i._320_/A fanout13/X
+ fanout47/X feedback_divider_i.configuration_decode_i._152_/C VDD VSS sg13cmos5l_nor3_1
Xoutput_divider_i._4_ output_divider_i._4_/X _1_/A enable VDD VSS sg13cmos5l_and2_1
Xfeedback_divider_i.configuration_decode_i._083_ feedback_divider_i._264_/A fanout46/X
+ feedback_divider_i.configuration_decode_i._148_/A fanout52/X feedback_divider_i.configuration_decode_i._086_/D
+ VDD VSS sg13cmos5l_nor4_1
XFILLER_5_261 VDD VSS sg13cmos5l_decap_8
Xinput4 input4/X div_ratio[3] VDD VSS sg13cmos5l_buf_1
XFILLER_2_275 VDD VSS sg13cmos5l_fill_1
XFILLER_4_0 VDD VSS sg13cmos5l_decap_8
Xfeedback_divider_i.configuration_decode_i._135_ feedback_divider_i._305_/A fanout44/X
+ fanout49/X feedback_divider_i.configuration_decode_i._153_/C feedback_divider_i.configuration_decode_i._137_/D
+ VDD VSS sg13cmos5l_and4_1
Xfeedback_divider_i.configuration_decode_i._066_ feedback_divider_i.configuration_decode_i._066_/Y
+ input4/X input3/X input2/X VDD VSS sg13cmos5l_a21oi_1
XFILLER_2_81 VDD VSS sg13cmos5l_fill_2
XFILLER_15_102 VDD VSS sg13cmos5l_fill_1
XFILLER_15_113 VDD VSS sg13cmos5l_fill_2
Xfeedback_divider_i.configuration_decode_i._118_ feedback_divider_i._290_/A fanout43/X
+ fanout49/X feedback_divider_i.configuration_decode_i._154_/C feedback_divider_i.configuration_decode_i._119_/D
+ VDD VSS sg13cmos5l_and4_1
Xfeedback_divider_i.configuration_decode_i._049_ feedback_divider_i.configuration_decode_i._049_/Y
+ fanout57/X fanout59/X feedback_divider_i.configuration_decode_i._048_/Y VDD VSS
+ sg13cmos5l_o21ai_1
XFILLER_21_149 VDD VSS sg13cmos5l_decap_8
XFILLER_16_46 VDD VSS sg13cmos5l_decap_8
Xfeedback_divider_i._531_ feedback_divider_i._531_/Q feedback_divider_i._535_/CLK
+ feedback_divider_i._531_/D fanout32/X VDD VSS sg13cmos5l_dfrbpq_2
Xfeedback_divider_i._462_ feedback_divider_i._462_/Y feedback_divider_i._492_/Q feedback_divider_i._313_/A
+ feedback_divider_i._515_/Q VDD VSS sg13cmos5l_a21oi_1
Xfeedback_divider_i._393_ feedback_divider_i._551_/D feedback_divider_i._499_/Q feedback_divider_i._279_/Y
+ feedback_divider_i._392_/Y VDD VSS sg13cmos5l_o21ai_1
XFILLER_1_307 VDD VSS sg13cmos5l_fill_2
XFILLER_16_241 VDD VSS sg13cmos5l_decap_4
XFILLER_16_263 VDD VSS sg13cmos5l_fill_2
XFILLER_4_189 VDD VSS sg13cmos5l_decap_8
Xfeedback_divider_i._514_ feedback_divider_i._514_/Q clkbuf_4_0_0_pll_clk_regs/X feedback_divider_i._514_/D
+ fanout22/X VDD VSS sg13cmos5l_dfrbpq_2
Xfeedback_divider_i._445_ feedback_divider_i._525_/D feedback_divider_i._493_/Q feedback_divider_i._305_/Y
+ feedback_divider_i._444_/Y VDD VSS sg13cmos5l_o21ai_1
Xfeedback_divider_i._376_ feedback_divider_i._376_/Y feedback_divider_i._502_/Q feedback_divider_i._270_/A
+ feedback_divider_i._558_/Q VDD VSS sg13cmos5l_a21oi_1
XFILLER_13_14 VDD VSS sg13cmos5l_decap_4
Xfanout15 fanout15/X fanout15/A VDD VSS sg13cmos5l_buf_1
Xfanout26 fanout26/X fanout29/X VDD VSS sg13cmos5l_buf_1
Xfanout37 fanout37/X fanout38/X VDD VSS sg13cmos5l_buf_1
Xfanout48 fanout48/X fanout49/X VDD VSS sg13cmos5l_buf_1
Xfanout59 fanout59/X input2/X VDD VSS sg13cmos5l_buf_1
XFILLER_0_181 VDD VSS sg13cmos5l_decap_8
XFILLER_5_92 VDD VSS sg13cmos5l_fill_2
Xfeedback_divider_i._359_ feedback_divider_i._568_/D feedback_divider_i._503_/Q feedback_divider_i._262_/Y
+ feedback_divider_i._580_/D VDD VSS sg13cmos5l_o21ai_1
Xfeedback_divider_i._428_ feedback_divider_i._428_/Y feedback_divider_i._496_/Q feedback_divider_i._296_/A
+ feedback_divider_i._532_/Q VDD VSS sg13cmos5l_a21oi_1
XFILLER_24_57 VDD VSS sg13cmos5l_fill_1
Xfeedback_divider_i.configuration_decode_i._151_ feedback_divider_i._319_/A fanout13/X
+ fanout48/X feedback_divider_i.configuration_decode_i._151_/C VDD VSS sg13cmos5l_nor3_1
Xfeedback_divider_i.configuration_decode_i._082_ feedback_divider_i.configuration_decode_i._148_/A
+ fanout56/X fanout54/X VDD VSS sg13cmos5l_nand2_1
XFILLER_5_251 VDD VSS sg13cmos5l_decap_4
Xinput5 input5/X div_ratio[4] VDD VSS sg13cmos5l_buf_1
XFILLER_19_68 VDD VSS sg13cmos5l_fill_1
XFILLER_27_111 VDD VSS sg13cmos5l_fill_2
XFILLER_27_133 VDD VSS sg13cmos5l_fill_2
XFILLER_18_100 VDD VSS sg13cmos5l_decap_8
XFILLER_2_265 VDD VSS sg13cmos5l_fill_2
Xfeedback_divider_i.configuration_decode_i._134_ feedback_divider_i._304_/A fanout51/X
+ feedback_divider_i.configuration_decode_i._152_/C fanout15/X VDD VSS sg13cmos5l_nor3_1
Xfeedback_divider_i.configuration_decode_i._065_ feedback_divider_i._256_/A feedback_divider_i.configuration_decode_i._065_/A
+ feedback_divider_i.configuration_decode_i._072_/A feedback_divider_i.configuration_decode_i._065_/C
+ VDD VSS sg13cmos5l_nor3_1
XFILLER_24_169 VDD VSS sg13cmos5l_fill_1
XFILLER_2_71 VDD VSS sg13cmos5l_fill_1
XFILLER_7_302 VDD VSS sg13cmos5l_decap_8
Xfeedback_divider_i.configuration_decode_i._117_ feedback_divider_i._289_/A fanout43/X
+ fanout49/X feedback_divider_i.configuration_decode_i._153_/C feedback_divider_i.configuration_decode_i._119_/D
+ VDD VSS sg13cmos5l_and4_1
XFILLER_14_191 VDD VSS sg13cmos5l_decap_8
Xfeedback_divider_i.configuration_decode_i._048_ feedback_divider_i.configuration_decode_i._048_/Y
+ fanout58/X fanout59/X VDD VSS sg13cmos5l_nand2b_1
XFILLER_4_305 VDD VSS sg13cmos5l_decap_4
Xfeedback_divider_i._530_ feedback_divider_i._530_/Q feedback_divider_i._535_/CLK
+ feedback_divider_i._530_/D fanout32/X VDD VSS sg13cmos5l_dfrbpq_2
Xfeedback_divider_i._461_ feedback_divider_i._517_/D feedback_divider_i._491_/Q feedback_divider_i._313_/Y
+ feedback_divider_i._460_/Y VDD VSS sg13cmos5l_o21ai_1
Xfeedback_divider_i._392_ feedback_divider_i._392_/Y feedback_divider_i._500_/Q feedback_divider_i._278_/A
+ feedback_divider_i._550_/Q VDD VSS sg13cmos5l_a21oi_1
XFILLER_19_261 VDD VSS sg13cmos5l_fill_1
XFILLER_4_28 VDD VSS sg13cmos5l_fill_1
Xfeedback_divider_i._513_ feedback_divider_i._513_/Q clkbuf_4_0_0_pll_clk_regs/X feedback_divider_i._513_/D
+ fanout22/X VDD VSS sg13cmos5l_dfrbpq_2
Xfeedback_divider_i._444_ feedback_divider_i._444_/Y feedback_divider_i._494_/Q feedback_divider_i._304_/A
+ feedback_divider_i._524_/Q VDD VSS sg13cmos5l_a21oi_1
Xfeedback_divider_i._375_ feedback_divider_i._560_/D feedback_divider_i._270_/Y feedback_divider_i._501_/Q
+ feedback_divider_i._374_/Y VDD VSS sg13cmos5l_o21ai_1
XFILLER_12_0 VDD VSS sg13cmos5l_decap_8
Xfanout16 fanout16/X fanout17/A VDD VSS sg13cmos5l_buf_1
Xfanout27 fanout27/X fanout29/X VDD VSS sg13cmos5l_buf_1
Xfanout38 fanout38/X fanout39/X VDD VSS sg13cmos5l_buf_1
Xfanout49 fanout49/X fanout50/X VDD VSS sg13cmos5l_buf_1
XFILLER_13_234 VDD VSS sg13cmos5l_fill_2
XFILLER_13_37 VDD VSS sg13cmos5l_decap_8
Xclkbuf_4_7_0_pll_clk_regs clkload0/A clkbuf_4_7_0_pll_clk_regs/A VDD VSS sg13cmos5l_buf_8
XFILLER_0_160 VDD VSS sg13cmos5l_decap_8
Xfeedback_divider_i._289_ feedback_divider_i._289_/Y feedback_divider_i._289_/A VDD
+ VSS sg13cmos5l_inv_2
Xfeedback_divider_i._358_ feedback_divider_i._581_/D feedback_divider_i._569_/Q feedback_divider_i._261_/Y
+ feedback_divider_i._357_/Y VDD VSS sg13cmos5l_o21ai_1
Xfeedback_divider_i._427_ feedback_divider_i._534_/D feedback_divider_i._495_/Q feedback_divider_i._296_/Y
+ feedback_divider_i._426_/Y VDD VSS sg13cmos5l_o21ai_1
Xfeedback_divider_i.configuration_decode_i._150_ feedback_divider_i._318_/A fanout13/X
+ fanout48/X feedback_divider_i.configuration_decode_i._150_/C VDD VSS sg13cmos5l_nor3_1
Xfeedback_divider_i.configuration_decode_i._081_ feedback_divider_i._263_/A fanout45/X
+ feedback_divider_i.configuration_decode_i._147_/A fanout52/X feedback_divider_i.configuration_decode_i._086_/D
+ VDD VSS sg13cmos5l_nor4_1
XFILLER_5_230 VDD VSS sg13cmos5l_decap_8
Xinput6 input6/X div_ratio[5] VDD VSS sg13cmos5l_buf_1
XFILLER_15_307 VDD VSS sg13cmos5l_fill_2
XFILLER_2_255 VDD VSS sg13cmos5l_decap_4
XFILLER_2_288 VDD VSS sg13cmos5l_decap_8
Xclkbuf_1_0_0_output_divider_i.div4_clk output_divider_i._5_/A1 clkbuf_0_output_divider_i.div4_clk/X
+ VDD VSS sg13cmos5l_buf_8
Xfeedback_divider_i.configuration_decode_i._133_ feedback_divider_i._303_/A fanout51/X
+ feedback_divider_i.configuration_decode_i._151_/C fanout15/X VDD VSS sg13cmos5l_nor3_1
Xfeedback_divider_i.configuration_decode_i._064_ feedback_divider_i._253_/A fanout63/X
+ feedback_divider_i.configuration_decode_i._045_/Y feedback_divider_i.configuration_decode_i._072_/C
+ VDD VSS sg13cmos5l_o21ai_1
XFILLER_18_189 VDD VSS sg13cmos5l_decap_8
XFILLER_24_104 VDD VSS sg13cmos5l_decap_8
XFILLER_21_48 VDD VSS sg13cmos5l_fill_2
XFILLER_23_192 VDD VSS sg13cmos5l_decap_4
XFILLER_11_92 VDD VSS sg13cmos5l_decap_4
Xfeedback_divider_i.configuration_decode_i._116_ feedback_divider_i._288_/A fanout51/X
+ feedback_divider_i.configuration_decode_i._152_/C fanout16/X VDD VSS sg13cmos5l_nor3_1
Xfeedback_divider_i.configuration_decode_i._047_ feedback_divider_i.configuration_decode_i._047_/Y
+ fanout58/X fanout20/X VDD VSS sg13cmos5l_nor2_1
XFILLER_12_129 VDD VSS sg13cmos5l_fill_2
XFILLER_20_162 VDD VSS sg13cmos5l_decap_8
XFILLER_7_111 VDD VSS sg13cmos5l_decap_4
XFILLER_7_166 VDD VSS sg13cmos5l_decap_8
Xfeedback_divider_i._460_ feedback_divider_i._460_/Y feedback_divider_i._492_/Q feedback_divider_i._312_/A
+ feedback_divider_i._516_/Q VDD VSS sg13cmos5l_a21oi_1
Xfeedback_divider_i._391_ feedback_divider_i._552_/D feedback_divider_i._278_/Y feedback_divider_i._499_/Q
+ feedback_divider_i._390_/Y VDD VSS sg13cmos5l_o21ai_1
XFILLER_8_71 VDD VSS sg13cmos5l_fill_1
Xfeedback_divider_i._589_ feedback_divider_i._589_/Q clkload0/A feedback_divider_i._589_/D
+ fanout28/X VDD VSS sg13cmos5l_dfrbpq_2
XFILLER_4_114 VDD VSS sg13cmos5l_fill_2
Xclkbuf_4_15_0_pll_clk_regs clkload1/A clkbuf_3_7_0_pll_clk_regs/X VDD VSS sg13cmos5l_buf_8
Xfeedback_divider_i._512_ feedback_divider_i._512_/Q clkbuf_4_2_0_pll_clk_regs/X feedback_divider_i._512_/D
+ fanout23/X VDD VSS sg13cmos5l_dfrbpq_2
Xfeedback_divider_i._443_ feedback_divider_i._526_/D feedback_divider_i._493_/Q feedback_divider_i._304_/Y
+ feedback_divider_i._442_/Y VDD VSS sg13cmos5l_o21ai_1
Xfeedback_divider_i._374_ feedback_divider_i._374_/Y feedback_divider_i._269_/A feedback_divider_i._502_/Q
+ feedback_divider_i._559_/Q VDD VSS sg13cmos5l_a21oi_1
XFILLER_13_224 VDD VSS sg13cmos5l_decap_4
Xfanout17 fanout17/X fanout17/A VDD VSS sg13cmos5l_buf_1
Xfanout28 fanout28/X fanout29/X VDD VSS sg13cmos5l_buf_1
Xfanout39 fanout39/X fanout39/A VDD VSS sg13cmos5l_buf_1
Xfeedback_divider_i._288_ feedback_divider_i._288_/Y feedback_divider_i._288_/A VDD
+ VSS sg13cmos5l_inv_2
Xfeedback_divider_i._357_ feedback_divider_i._357_/Y feedback_divider_i._596_/Q feedback_divider_i._570_/Q
+ feedback_divider_i._571_/Q feedback_divider_i._581_/Q VDD VSS sg13cmos5l_a22oi_1
Xpfd_i._09__70 pfd_i._09_/D VDD VSS sg13cmos5l_tiehi
Xfeedback_divider_i._426_ feedback_divider_i._426_/Y feedback_divider_i._496_/Q feedback_divider_i._295_/A
+ feedback_divider_i._533_/Q VDD VSS sg13cmos5l_a21oi_1
XFILLER_24_48 VDD VSS sg13cmos5l_fill_1
XFILLER_8_294 VDD VSS sg13cmos5l_decap_8
Xfeedback_divider_i.configuration_decode_i._080_ feedback_divider_i.configuration_decode_i._147_/A
+ fanout56/X fanout54/X VDD VSS sg13cmos5l_nand2b_1
Xinput7 input7/X div_ratio[6] VDD VSS sg13cmos5l_buf_1
Xfeedback_divider_i._409_ feedback_divider_i._543_/D feedback_divider_i._497_/Q feedback_divider_i._287_/Y
+ feedback_divider_i._408_/Y VDD VSS sg13cmos5l_o21ai_1
XFILLER_27_113 VDD VSS sg13cmos5l_fill_1
XFILLER_27_135 VDD VSS sg13cmos5l_fill_1
XFILLER_2_267 VDD VSS sg13cmos5l_fill_1
Xfeedback_divider_i.configuration_decode_i._132_ feedback_divider_i._302_/A fanout51/X
+ feedback_divider_i.configuration_decode_i._150_/C fanout15/X VDD VSS sg13cmos5l_nor3_1
Xfeedback_divider_i.configuration_decode_i._063_ feedback_divider_i._252_/A feedback_divider_i.configuration_decode_i._041_/Y
+ fanout20/A feedback_divider_i.configuration_decode_i._054_/Y feedback_divider_i.configuration_decode_i._061_/Y
+ VDD VSS sg13cmos5l_a22oi_1
XFILLER_2_62 VDD VSS sg13cmos5l_fill_2
XFILLER_2_0 VDD VSS sg13cmos5l_decap_8
Xfeedback_divider_i.configuration_decode_i._115_ feedback_divider_i._287_/A fanout52/X
+ feedback_divider_i.configuration_decode_i._151_/C fanout16/X VDD VSS sg13cmos5l_nor3_1
Xfeedback_divider_i.configuration_decode_i._046_ feedback_divider_i.configuration_decode_i._065_/A
+ fanout57/X fanout59/X VDD VSS sg13cmos5l_nor2_1
Xinput10 input10/X div_ratio[9] VDD VSS sg13cmos5l_buf_1
Xpfd_i._09_ up ref_clk pfd_i._09_/D pfd_i._06_/Y VDD VSS sg13cmos5l_dfrbpq_2
XFILLER_7_145 VDD VSS sg13cmos5l_decap_8
Xfeedback_divider_i._390_ feedback_divider_i._390_/Y feedback_divider_i._277_/A feedback_divider_i._500_/Q
+ feedback_divider_i._551_/Q VDD VSS sg13cmos5l_a21oi_1
XFILLER_8_94 VDD VSS sg13cmos5l_decap_8
Xfeedback_divider_i._588_ feedback_divider_i._588_/Q feedback_divider_i._588_/CLK
+ feedback_divider_i._588_/D fanout36/X VDD VSS sg13cmos5l_dfrbpq_2
XFILLER_25_211 VDD VSS sg13cmos5l_decap_8
Xclkbuf_2_0_0_pll_clk_regs clkbuf_3_1_0_pll_clk_regs/A clkbuf_2_1_0_pll_clk_regs/A
+ VDD VSS sg13cmos5l_buf_8
Xfeedback_divider_i._511_ feedback_divider_i._511_/Q clkbuf_4_3_0_pll_clk_regs/X feedback_divider_i._511_/D
+ fanout22/X VDD VSS sg13cmos5l_dfrbpq_2
Xfeedback_divider_i._442_ feedback_divider_i._442_/Y feedback_divider_i._494_/Q feedback_divider_i._303_/A
+ feedback_divider_i._525_/Q VDD VSS sg13cmos5l_a21oi_1
Xfeedback_divider_i._373_ feedback_divider_i._561_/D feedback_divider_i._503_/Q feedback_divider_i._269_/Y
+ feedback_divider_i._372_/Y VDD VSS sg13cmos5l_o21ai_1
Xfanout18 fanout18/X fanout19/X VDD VSS sg13cmos5l_buf_1
Xfanout29 fanout29/X fanout39/X VDD VSS sg13cmos5l_buf_1
XFILLER_0_151 VDD VSS sg13cmos5l_decap_4
XFILLER_28_80 VDD VSS sg13cmos5l_fill_1
XFILLER_9_207 VDD VSS sg13cmos5l_decap_8
Xfeedback_divider_i._356_ feedback_divider_i._582_/D feedback_divider_i._569_/Q feedback_divider_i._260_/Y
+ feedback_divider_i._355_/Y VDD VSS sg13cmos5l_o21ai_1
Xfeedback_divider_i._425_ feedback_divider_i._535_/D feedback_divider_i._495_/Q feedback_divider_i._295_/Y
+ feedback_divider_i._424_/Y VDD VSS sg13cmos5l_o21ai_1
XFILLER_8_273 VDD VSS sg13cmos5l_decap_4
Xfeedback_divider_i._287_ feedback_divider_i._287_/Y feedback_divider_i._287_/A VDD
+ VSS sg13cmos5l_inv_2
XFILLER_18_306 VDD VSS sg13cmos5l_fill_2
XFILLER_6_7 VDD VSS sg13cmos5l_decap_8
XFILLER_14_93 VDD VSS sg13cmos5l_fill_1
Xclkbuf_4_3_0_pll_clk_regs clkbuf_4_3_0_pll_clk_regs/X clkbuf_4_3_0_pll_clk_regs/A
+ VDD VSS sg13cmos5l_buf_8
Xfeedback_divider_i._339_ feedback_divider_i._339_/Y feedback_divider_i._577_/Q feedback_divider_i._590_/Q
+ feedback_divider_i._589_/Q feedback_divider_i._576_/Q VDD VSS sg13cmos5l_a22oi_1
Xinput8 input8/X div_ratio[7] VDD VSS sg13cmos5l_buf_1
Xfeedback_divider_i._408_ feedback_divider_i._408_/Y feedback_divider_i._498_/Q feedback_divider_i._286_/A
+ feedback_divider_i._542_/Q VDD VSS sg13cmos5l_a21oi_1
XFILLER_2_202 VDD VSS sg13cmos5l_decap_8
XFILLER_2_213 VDD VSS sg13cmos5l_fill_1
Xfeedback_divider_i.configuration_decode_i._131_ feedback_divider_i._301_/A feedback_divider_i.configuration_decode_i._149_/A
+ fanout14/X VDD VSS sg13cmos5l_nor2_1
Xfeedback_divider_i.configuration_decode_i._062_ feedback_divider_i._255_/A fanout63/X
+ feedback_divider_i.configuration_decode_i._072_/C feedback_divider_i.configuration_decode_i._054_/Y
+ VDD VSS sg13cmos5l_o21ai_1
XFILLER_18_114 VDD VSS sg13cmos5l_decap_8
XFILLER_18_136 VDD VSS sg13cmos5l_fill_1
XFILLER_15_128 VDD VSS sg13cmos5l_fill_1
Xfeedback_divider_i.configuration_decode_i._114_ feedback_divider_i._286_/A fanout52/X
+ feedback_divider_i.configuration_decode_i._150_/C fanout16/X VDD VSS sg13cmos5l_nor3_1
Xfeedback_divider_i.configuration_decode_i._045_ feedback_divider_i.configuration_decode_i._045_/Y
+ fanout58/X fanout59/X VDD VSS sg13cmos5l_nor2_1
XFILLER_16_39 VDD VSS sg13cmos5l_decap_8
XFILLER_28_0 VDD VSS sg13cmos5l_decap_4
Xinput11 _1_/A reset_n VDD VSS sg13cmos5l_buf_1
Xpfd_i._08_ down feedback_clk pfd_i._08_/D pfd_i._07_/Y VDD VSS sg13cmos5l_dfrbpq_2
XFILLER_11_120 VDD VSS sg13cmos5l_decap_8
Xfeedback_divider_i._587_ feedback_divider_i._587_/Q feedback_divider_i._588_/CLK
+ feedback_divider_i._587_/D fanout36/X VDD VSS sg13cmos5l_dfrbpq_2
XFILLER_0_300 VDD VSS sg13cmos5l_decap_8
XFILLER_16_256 VDD VSS sg13cmos5l_fill_2
XFILLER_17_82 VDD VSS sg13cmos5l_fill_2
XFILLER_4_127 VDD VSS sg13cmos5l_decap_4
Xfeedback_divider_i._510_ feedback_divider_i._510_/Q clkbuf_4_3_0_pll_clk_regs/X feedback_divider_i._510_/D
+ fanout21/X VDD VSS sg13cmos5l_dfrbpq_2
Xfeedback_divider_i._441_ feedback_divider_i._527_/D feedback_divider_i._493_/Q feedback_divider_i._303_/Y
+ feedback_divider_i._440_/Y VDD VSS sg13cmos5l_o21ai_1
Xfeedback_divider_i._372_ feedback_divider_i._372_/Y feedback_divider_i._504_/Q feedback_divider_i._268_/A
+ feedback_divider_i._560_/Q VDD VSS sg13cmos5l_a21oi_1
XFILLER_13_18 VDD VSS sg13cmos5l_fill_1
Xfanout19 fanout19/X fanout19/A VDD VSS sg13cmos5l_buf_1
XFILLER_0_174 VDD VSS sg13cmos5l_decap_8
XFILLER_10_0 VDD VSS sg13cmos5l_decap_8
Xclkbuf_4_11_0_pll_clk_regs feedback_divider_i._597_/CLK clkbuf_3_5_0_pll_clk_regs/X
+ VDD VSS sg13cmos5l_buf_8
Xfeedback_divider_i._286_ feedback_divider_i._286_/Y feedback_divider_i._286_/A VDD
+ VSS sg13cmos5l_inv_2
Xfeedback_divider_i._355_ feedback_divider_i._355_/Y feedback_divider_i._571_/Q feedback_divider_i._582_/Q
+ feedback_divider_i._581_/Q feedback_divider_i._570_/Q VDD VSS sg13cmos5l_a22oi_1
Xfeedback_divider_i._424_ feedback_divider_i._424_/Y feedback_divider_i._496_/Q feedback_divider_i._294_/A
+ feedback_divider_i._534_/Q VDD VSS sg13cmos5l_a21oi_1
Xfeedback_divider_i._572__67 feedback_divider_i._572_/D VDD VSS sg13cmos5l_tiehi
XFILLER_5_200 VDD VSS sg13cmos5l_fill_1
XFILLER_5_244 VDD VSS sg13cmos5l_decap_8
Xfeedback_divider_i._269_ feedback_divider_i._269_/Y feedback_divider_i._269_/A VDD
+ VSS sg13cmos5l_inv_2
Xfeedback_divider_i._338_ feedback_divider_i._591_/D feedback_divider_i._575_/Q feedback_divider_i._251_/Y
+ feedback_divider_i._337_/Y VDD VSS sg13cmos5l_o21ai_1
Xinput9 input9/X div_ratio[8] VDD VSS sg13cmos5l_buf_1
Xfeedback_divider_i._407_ feedback_divider_i._544_/D feedback_divider_i._286_/Y feedback_divider_i._497_/Q
+ feedback_divider_i._406_/Y VDD VSS sg13cmos5l_o21ai_1
XFILLER_27_126 VDD VSS sg13cmos5l_decap_8
Xfeedback_divider_i.configuration_decode_i._130_ feedback_divider_i._300_/A feedback_divider_i.configuration_decode_i._148_/A
+ fanout18/X fanout15/X VDD VSS sg13cmos5l_nor3_1
XFILLER_18_126 VDD VSS sg13cmos5l_decap_4
XFILLER_18_148 VDD VSS sg13cmos5l_fill_2
XFILLER_2_247 VDD VSS sg13cmos5l_fill_2
X_1_ _1_/X _1_/A enable VDD VSS sg13cmos5l_and2_1
Xfeedback_divider_i.configuration_decode_i._061_ feedback_divider_i.configuration_decode_i._061_/Y
+ fanout63/X input4/X VDD VSS sg13cmos5l_nand2b_1
XFILLER_24_118 VDD VSS sg13cmos5l_decap_4
XFILLER_2_42 VDD VSS sg13cmos5l_decap_8
XFILLER_11_51 VDD VSS sg13cmos5l_fill_1
XFILLER_23_140 VDD VSS sg13cmos5l_decap_8
Xfeedback_divider_i.configuration_decode_i._113_ feedback_divider_i._285_/A feedback_divider_i.configuration_decode_i._149_/A
+ fanout16/X VDD VSS sg13cmos5l_nor2_1
Xfeedback_divider_i.configuration_decode_i._044_ feedback_divider_i._254_/A feedback_divider_i.configuration_decode_i._044_/A
+ VDD VSS sg13cmos5l_inv_2
XFILLER_14_184 VDD VSS sg13cmos5l_decap_8
Xpfd_i._07_ pfd_i._07_/Y up down pfd_i._05_/Y VDD VSS sg13cmos5l_a21oi_1
XFILLER_11_198 VDD VSS sg13cmos5l_decap_4
XFILLER_14_7 VDD VSS sg13cmos5l_decap_8
XFILLER_22_61 VDD VSS sg13cmos5l_decap_8
Xfeedback_divider_i._586_ feedback_divider_i._586_/Q feedback_divider_i._588_/CLK
+ feedback_divider_i._586_/D fanout36/X VDD VSS sg13cmos5l_dfrbpq_2
XFILLER_27_39 VDD VSS sg13cmos5l_decap_4
XFILLER_17_61 VDD VSS sg13cmos5l_decap_8
Xfeedback_divider_i._440_ feedback_divider_i._440_/Y feedback_divider_i._494_/Q feedback_divider_i._302_/A
+ feedback_divider_i._526_/Q VDD VSS sg13cmos5l_a21oi_1
Xfeedback_divider_i._371_ feedback_divider_i._562_/D feedback_divider_i._503_/Q feedback_divider_i._268_/Y
+ feedback_divider_i._370_/Y VDD VSS sg13cmos5l_o21ai_1
Xfeedback_divider_i._569_ feedback_divider_i._569_/Q clkbuf_4_5_0_pll_clk_regs/X feedback_divider_i._569_/D
+ fanout25/X VDD VSS sg13cmos5l_dfrbpq_2
XFILLER_28_71 VDD VSS sg13cmos5l_decap_8
XFILLER_28_93 VDD VSS sg13cmos5l_decap_8
XFILLER_5_42 VDD VSS sg13cmos5l_decap_8
XFILLER_8_253 VDD VSS sg13cmos5l_fill_2
Xfeedback_divider_i._285_ feedback_divider_i._285_/Y feedback_divider_i._285_/A VDD
+ VSS sg13cmos5l_inv_2
Xfeedback_divider_i._354_ feedback_divider_i._583_/D feedback_divider_i._569_/Q feedback_divider_i._259_/Y
+ feedback_divider_i._353_/Y VDD VSS sg13cmos5l_o21ai_1
Xfeedback_divider_i._423_ feedback_divider_i._536_/D feedback_divider_i._294_/Y feedback_divider_i._495_/Q
+ feedback_divider_i._422_/Y VDD VSS sg13cmos5l_o21ai_1
XFILLER_18_308 VDD VSS sg13cmos5l_fill_1
XFILLER_24_18 VDD VSS sg13cmos5l_decap_8
Xfeedback_divider_i._406_ feedback_divider_i._406_/Y feedback_divider_i._285_/A feedback_divider_i._498_/Q
+ feedback_divider_i._543_/Q VDD VSS sg13cmos5l_a21oi_1
Xfeedback_divider_i._268_ feedback_divider_i._268_/Y feedback_divider_i._268_/A VDD
+ VSS sg13cmos5l_inv_2
Xfeedback_divider_i._337_ feedback_divider_i._337_/Y feedback_divider_i._591_/Q feedback_divider_i._577_/Q
+ feedback_divider_i._590_/Q feedback_divider_i._576_/Q VDD VSS sg13cmos5l_a22oi_1
XFILLER_26_160 VDD VSS sg13cmos5l_fill_1
XFILLER_2_259 VDD VSS sg13cmos5l_fill_2
Xfeedback_divider_i.configuration_decode_i._060_ feedback_divider_i._251_/A feedback_divider_i.configuration_decode_i._065_/A
+ feedback_divider_i.configuration_decode_i._060_/B feedback_divider_i.configuration_decode_i._065_/C
+ VDD VSS sg13cmos5l_nor3_1
XFILLER_17_182 VDD VSS sg13cmos5l_decap_4
XFILLER_2_21 VDD VSS sg13cmos5l_fill_1
Xfeedback_divider_i.configuration_decode_i._112_ feedback_divider_i._284_/A feedback_divider_i.configuration_decode_i._148_/A
+ fanout19/X fanout17/X VDD VSS sg13cmos5l_nor3_1
Xfeedback_divider_i.configuration_decode_i._043_ feedback_divider_i.configuration_decode_i._044_/A
+ fanout57/X fanout62/X VDD VSS sg13cmos5l_nand2_1
XFILLER_11_85 VDD VSS sg13cmos5l_decap_8
XFILLER_11_96 VDD VSS sg13cmos5l_fill_1
Xpfd_i._06_ pfd_i._06_/Y up down pfd_i._05_/Y VDD VSS sg13cmos5l_a21oi_1
XFILLER_20_155 VDD VSS sg13cmos5l_decap_8
Xclkbuf_3_5_0_pll_clk_regs clkbuf_3_5_0_pll_clk_regs/X clkbuf_3_5_0_pll_clk_regs/A
+ VDD VSS sg13cmos5l_buf_8
XFILLER_0_0 VDD VSS sg13cmos5l_decap_8
XFILLER_11_166 VDD VSS sg13cmos5l_fill_2
XFILLER_7_104 VDD VSS sg13cmos5l_decap_8
XFILLER_7_115 VDD VSS sg13cmos5l_fill_2
XFILLER_7_159 VDD VSS sg13cmos5l_decap_8
Xfeedback_divider_i._585_ feedback_divider_i._585_/Q feedback_divider_i._588_/CLK
+ feedback_divider_i._585_/D fanout36/X VDD VSS sg13cmos5l_dfrbpq_2
XFILLER_4_107 VDD VSS sg13cmos5l_fill_1
Xfeedback_divider_i._370_ feedback_divider_i._370_/Y feedback_divider_i._504_/Q feedback_divider_i._267_/A
+ feedback_divider_i._561_/Q VDD VSS sg13cmos5l_a21oi_1
Xfeedback_divider_i._568_ feedback_divider_i._597_/D feedback_divider_i._597_/CLK
+ feedback_divider_i._568_/D fanout33/X VDD VSS sg13cmos5l_dfrbpq_2
Xfeedback_divider_i._499_ feedback_divider_i._499_/Q feedback_divider_i._561_/CLK
+ feedback_divider_i._503_/D fanout35/X VDD VSS sg13cmos5l_dfrbpq_2
XFILLER_13_217 VDD VSS sg13cmos5l_fill_2
XFILLER_13_228 VDD VSS sg13cmos5l_fill_1
XFILLER_12_261 VDD VSS sg13cmos5l_decap_8
XFILLER_12_272 VDD VSS sg13cmos5l_fill_1
XFILLER_5_21 VDD VSS sg13cmos5l_decap_8
XFILLER_8_210 VDD VSS sg13cmos5l_decap_8
XFILLER_8_221 VDD VSS sg13cmos5l_fill_1
Xfeedback_divider_i._284_ feedback_divider_i._284_/Y feedback_divider_i._284_/A VDD
+ VSS sg13cmos5l_inv_2
Xfeedback_divider_i._353_ feedback_divider_i._353_/Y feedback_divider_i._583_/Q feedback_divider_i._571_/Q
+ feedback_divider_i._582_/Q feedback_divider_i._570_/Q VDD VSS sg13cmos5l_a22oi_1
Xfeedback_divider_i._422_ feedback_divider_i._422_/Y feedback_divider_i._293_/A feedback_divider_i._496_/Q
+ feedback_divider_i._535_/Q VDD VSS sg13cmos5l_a21oi_1
XFILLER_5_268 VDD VSS sg13cmos5l_fill_2
XFILLER_5_279 VDD VSS sg13cmos5l_fill_1
Xfeedback_divider_i._267_ feedback_divider_i._267_/Y feedback_divider_i._267_/A VDD
+ VSS sg13cmos5l_inv_2
Xfeedback_divider_i._336_ feedback_divider_i._592_/D feedback_divider_i._575_/Q feedback_divider_i._250_/Y
+ feedback_divider_i._335_/Y VDD VSS sg13cmos5l_o21ai_1
Xfeedback_divider_i._405_ feedback_divider_i._545_/D feedback_divider_i._499_/Q feedback_divider_i._285_/Y
+ feedback_divider_i._404_/Y VDD VSS sg13cmos5l_o21ai_1
XFILLER_2_249 VDD VSS sg13cmos5l_fill_1
XFILLER_4_7 VDD VSS sg13cmos5l_decap_8
XFILLER_14_301 VDD VSS sg13cmos5l_decap_8
XFILLER_1_282 VDD VSS sg13cmos5l_decap_8
XFILLER_2_88 VDD VSS sg13cmos5l_fill_2
Xfeedback_divider_i._319_ feedback_divider_i._319_/Y feedback_divider_i._319_/A VDD
+ VSS sg13cmos5l_inv_2
XFILLER_15_109 VDD VSS sg13cmos5l_decap_4
XFILLER_20_304 VDD VSS sg13cmos5l_decap_4
Xfeedback_divider_i.configuration_decode_i._111_ feedback_divider_i._283_/A feedback_divider_i.configuration_decode_i._147_/A
+ fanout19/X fanout17/X VDD VSS sg13cmos5l_nor3_1
Xpfd_i._05_ pfd_i._05_/Y _1_/X VDD VSS sg13cmos5l_inv_2
Xfeedback_divider_i.configuration_decode_i._042_ fanout20/A fanout59/X VDD VSS sg13cmos5l_inv_2
XFILLER_11_134 VDD VSS sg13cmos5l_decap_4
XFILLER_11_156 VDD VSS sg13cmos5l_fill_2
XFILLER_7_138 VDD VSS sg13cmos5l_decap_8
XFILLER_26_0 VDD VSS sg13cmos5l_decap_4
XFILLER_6_160 VDD VSS sg13cmos5l_fill_1
XFILLER_8_54 VDD VSS sg13cmos5l_decap_4
XFILLER_8_87 VDD VSS sg13cmos5l_decap_8
Xfeedback_divider_i._584_ feedback_divider_i._584_/Q clkbuf_4_5_0_pll_clk_regs/X feedback_divider_i._584_/D
+ fanout26/X VDD VSS sg13cmos5l_dfrbpq_2
XFILLER_25_204 VDD VSS sg13cmos5l_decap_8
XFILLER_16_226 VDD VSS sg13cmos5l_fill_2
XFILLER_3_163 VDD VSS sg13cmos5l_decap_4
Xfeedback_divider_i._567_ feedback_divider_i._579_/D clkload1/A feedback_divider_i._567_/D
+ fanout36/X VDD VSS sg13cmos5l_dfrbpq_2
Xfeedback_divider_i._498_ feedback_divider_i._498_/Q feedback_divider_i._561_/CLK
+ feedback_divider_i._504_/D fanout35/X VDD VSS sg13cmos5l_dfrbpq_2
XFILLER_0_144 VDD VSS sg13cmos5l_decap_8
XFILLER_0_188 VDD VSS sg13cmos5l_decap_8
XFILLER_21_240 VDD VSS sg13cmos5l_decap_4
Xfeedback_divider_i._283_ feedback_divider_i._283_/Y feedback_divider_i._283_/A VDD
+ VSS sg13cmos5l_inv_2
Xfeedback_divider_i._352_ feedback_divider_i._584_/D feedback_divider_i._569_/Q feedback_divider_i._258_/Y
+ feedback_divider_i._351_/Y VDD VSS sg13cmos5l_o21ai_1
Xfeedback_divider_i._421_ feedback_divider_i._537_/D feedback_divider_i._497_/Q feedback_divider_i._293_/Y
+ feedback_divider_i._420_/Y VDD VSS sg13cmos5l_o21ai_1
XFILLER_5_99 VDD VSS sg13cmos5l_decap_8
XFILLER_8_233 VDD VSS sg13cmos5l_fill_2
XFILLER_8_266 VDD VSS sg13cmos5l_decap_8
XFILLER_4_291 VDD VSS sg13cmos5l_decap_8
Xfeedback_divider_i._266_ feedback_divider_i._266_/Y feedback_divider_i._266_/A VDD
+ VSS sg13cmos5l_inv_2
Xfeedback_divider_i._335_ feedback_divider_i._335_/Y feedback_divider_i._576_/Q feedback_divider_i._591_/Q
+ feedback_divider_i._577_/Q feedback_divider_i._592_/Q VDD VSS sg13cmos5l_a22oi_1
Xfeedback_divider_i._404_ feedback_divider_i._404_/Y feedback_divider_i._500_/Q feedback_divider_i._284_/A
+ feedback_divider_i._544_/Q VDD VSS sg13cmos5l_a21oi_1
XFILLER_18_107 VDD VSS sg13cmos5l_decap_8
XFILLER_26_173 VDD VSS sg13cmos5l_decap_8
XFILLER_2_56 VDD VSS sg13cmos5l_fill_1
Xfeedback_divider_i._249_ feedback_divider_i._249_/Y feedback_divider_i._249_/A VDD
+ VSS sg13cmos5l_inv_2
Xfeedback_divider_i._318_ feedback_divider_i._318_/Y feedback_divider_i._318_/A VDD
+ VSS sg13cmos5l_inv_2
XFILLER_23_132 VDD VSS sg13cmos5l_fill_2
XFILLER_23_154 VDD VSS sg13cmos5l_decap_4
Xfeedback_divider_i.configuration_decode_i._110_ feedback_divider_i._282_/A feedback_divider_i.configuration_decode_i._146_/A
+ fanout19/A fanout17/X VDD VSS sg13cmos5l_nor3_1
Xfeedback_divider_i.configuration_decode_i._041_ feedback_divider_i.configuration_decode_i._041_/Y
+ fanout58/X VDD VSS sg13cmos5l_inv_2
XFILLER_14_198 VDD VSS sg13cmos5l_decap_4
XFILLER_28_4 VDD VSS sg13cmos5l_fill_1
XFILLER_11_113 VDD VSS sg13cmos5l_decap_8
XFILLER_11_168 VDD VSS sg13cmos5l_fill_1
Xfeedback_divider_i._583_ feedback_divider_i._583_/Q clkbuf_4_5_0_pll_clk_regs/X feedback_divider_i._583_/D
+ fanout26/X VDD VSS sg13cmos5l_dfrbpq_2
XFILLER_16_249 VDD VSS sg13cmos5l_decap_8
XFILLER_17_75 VDD VSS sg13cmos5l_decap_8
XFILLER_3_142 VDD VSS sg13cmos5l_decap_8
XFILLER_3_153 VDD VSS sg13cmos5l_fill_1
Xclkbuf_3_1_0_pll_clk_regs clkbuf_4_3_0_pll_clk_regs/A clkbuf_3_1_0_pll_clk_regs/A
+ VDD VSS sg13cmos5l_buf_8
Xfeedback_divider_i._566_ feedback_divider_i._566_/Q clkload1/A feedback_divider_i._566_/D
+ fanout38/X VDD VSS sg13cmos5l_dfrbpq_2
XFILLER_12_7 VDD VSS sg13cmos5l_fill_2
XFILLER_15_282 VDD VSS sg13cmos5l_decap_8
Xfeedback_divider_i._497_ feedback_divider_i._497_/Q clkbuf_4_3_0_pll_clk_regs/X feedback_divider_i._503_/D
+ fanout31/X VDD VSS sg13cmos5l_dfrbpq_2
XFILLER_0_112 VDD VSS sg13cmos5l_decap_4
XFILLER_0_167 VDD VSS sg13cmos5l_decap_8
XFILLER_13_219 VDD VSS sg13cmos5l_fill_1
XFILLER_28_41 VDD VSS sg13cmos5l_decap_8
Xfeedback_divider_i._282_ feedback_divider_i._282_/Y feedback_divider_i._282_/A VDD
+ VSS sg13cmos5l_inv_2
Xfeedback_divider_i._351_ feedback_divider_i._351_/Y feedback_divider_i._570_/Q feedback_divider_i._583_/Q
+ feedback_divider_i._571_/Q feedback_divider_i._584_/Q VDD VSS sg13cmos5l_a22oi_1
Xfeedback_divider_i._575__68 feedback_divider_i._575_/D VDD VSS sg13cmos5l_tiehi
Xfeedback_divider_i._420_ feedback_divider_i._420_/Y feedback_divider_i._498_/Q feedback_divider_i._292_/A
+ feedback_divider_i._536_/Q VDD VSS sg13cmos5l_a21oi_1
XFILLER_5_78 VDD VSS sg13cmos5l_fill_1
XFILLER_8_201 VDD VSS sg13cmos5l_fill_2
Xfeedback_divider_i._549_ feedback_divider_i._549_/Q feedback_divider_i._551_/CLK
+ feedback_divider_i._549_/D fanout37/X VDD VSS sg13cmos5l_dfrbpq_2
XFILLER_5_237 VDD VSS sg13cmos5l_decap_8
Xfeedback_divider_i._265_ feedback_divider_i._265_/Y feedback_divider_i._265_/A VDD
+ VSS sg13cmos5l_inv_2
Xfeedback_divider_i._334_ feedback_divider_i._593_/D feedback_divider_i._578_/Q feedback_divider_i._249_/Y
+ feedback_divider_i._333_/Y VDD VSS sg13cmos5l_o21ai_1
Xfeedback_divider_i._403_ feedback_divider_i._546_/D feedback_divider_i._499_/Q feedback_divider_i._284_/Y
+ feedback_divider_i._402_/Y VDD VSS sg13cmos5l_o21ai_1
XFILLER_27_119 VDD VSS sg13cmos5l_decap_8
XFILLER_25_86 VDD VSS sg13cmos5l_fill_1
XFILLER_26_130 VDD VSS sg13cmos5l_decap_8
XFILLER_26_152 VDD VSS sg13cmos5l_fill_2
XFILLER_2_35 VDD VSS sg13cmos5l_decap_8
Xfeedback_divider_i._248_ feedback_divider_i._248_/Y feedback_divider_i._248_/A VDD
+ VSS sg13cmos5l_inv_2
Xfeedback_divider_i._317_ feedback_divider_i._317_/Y feedback_divider_i._317_/A VDD
+ VSS sg13cmos5l_inv_2
XFILLER_11_33 VDD VSS sg13cmos5l_fill_2
Xfeedback_divider_i.configuration_decode_i._040_ feedback_divider_i.configuration_decode_i._072_/C
+ fanout57/X VDD VSS sg13cmos5l_inv_2
XFILLER_20_169 VDD VSS sg13cmos5l_fill_1
XFILLER_19_247 VDD VSS sg13cmos5l_fill_1
XFILLER_22_54 VDD VSS sg13cmos5l_fill_2
XFILLER_8_23 VDD VSS sg13cmos5l_fill_2
Xfeedback_divider_i._582_ feedback_divider_i._582_/Q clkbuf_4_5_0_pll_clk_regs/X feedback_divider_i._582_/D
+ fanout26/X VDD VSS sg13cmos5l_dfrbpq_2
XFILLER_18_280 VDD VSS sg13cmos5l_decap_8
XFILLER_18_291 VDD VSS sg13cmos5l_fill_2
XFILLER_17_54 VDD VSS sg13cmos5l_decap_8
XFILLER_3_121 VDD VSS sg13cmos5l_decap_8
Xfeedback_divider_i._569__66 feedback_divider_i._569_/D VDD VSS sg13cmos5l_tiehi
Xfeedback_divider_i._565_ feedback_divider_i._565_/Q clkload1/A feedback_divider_i._565_/D
+ fanout38/X VDD VSS sg13cmos5l_dfrbpq_2
Xfeedback_divider_i._496_ feedback_divider_i._496_/Q feedback_divider_i._535_/CLK
+ feedback_divider_i._504_/D fanout32/X VDD VSS sg13cmos5l_dfrbpq_2
Xfeedback_divider_i._350_ feedback_divider_i._585_/D feedback_divider_i._572_/Q feedback_divider_i._257_/Y
+ feedback_divider_i._349_/Y VDD VSS sg13cmos5l_o21ai_1
XFILLER_5_35 VDD VSS sg13cmos5l_decap_8
XFILLER_8_235 VDD VSS sg13cmos5l_fill_1
XFILLER_8_246 VDD VSS sg13cmos5l_decap_8
Xfeedback_divider_i._281_ feedback_divider_i._281_/Y feedback_divider_i._281_/A VDD
+ VSS sg13cmos5l_inv_2
Xfeedback_divider_i._548_ feedback_divider_i._548_/Q feedback_divider_i._551_/CLK
+ feedback_divider_i._548_/D fanout37/X VDD VSS sg13cmos5l_dfrbpq_2
Xfeedback_divider_i._479_ feedback_divider_i._508_/D feedback_divider_i._489_/Q feedback_divider_i._322_/Y
+ feedback_divider_i._478_/Y VDD VSS sg13cmos5l_o21ai_1
XFILLER_14_99 VDD VSS sg13cmos5l_fill_2
Xfeedback_divider_i._264_ feedback_divider_i._264_/Y feedback_divider_i._264_/A VDD
+ VSS sg13cmos5l_inv_2
Xfeedback_divider_i._333_ feedback_divider_i._333_/Y feedback_divider_i._580_/Q feedback_divider_i._593_/Q
+ feedback_divider_i._592_/Q feedback_divider_i._579_/Q VDD VSS sg13cmos5l_a22oi_1
Xfeedback_divider_i._402_ feedback_divider_i._402_/Y feedback_divider_i._500_/Q feedback_divider_i._283_/A
+ feedback_divider_i._545_/Q VDD VSS sg13cmos5l_a21oi_1
XFILLER_17_175 VDD VSS sg13cmos5l_decap_8
XFILLER_17_186 VDD VSS sg13cmos5l_fill_2
XFILLER_1_296 VDD VSS sg13cmos5l_decap_8
XFILLER_2_14 VDD VSS sg13cmos5l_decap_8
XFILLER_2_69 VDD VSS sg13cmos5l_fill_2
Xfeedback_divider_i._247_ feedback_divider_i._247_/Y fanout57/X VDD VSS sg13cmos5l_inv_2
Xfeedback_divider_i._316_ feedback_divider_i._316_/Y feedback_divider_i._316_/A VDD
+ VSS sg13cmos5l_inv_2
XFILLER_2_7 VDD VSS sg13cmos5l_decap_8
XFILLER_14_101 VDD VSS sg13cmos5l_fill_1
Xfeedback_divider_i.configuration_decode_i._099_ feedback_divider_i._274_/A fanout42/X
+ fanout47/X feedback_divider_i.configuration_decode_i._100_/C feedback_divider_i.configuration_decode_i._154_/C
+ VDD VSS sg13cmos5l_and4_1
XFILLER_20_148 VDD VSS sg13cmos5l_decap_8
XFILLER_9_193 VDD VSS sg13cmos5l_decap_8
Xfeedback_divider_i._581_ feedback_divider_i._581_/Q clkbuf_4_5_0_pll_clk_regs/X feedback_divider_i._581_/D
+ fanout25/X VDD VSS sg13cmos5l_dfrbpq_2
Xfeedback_divider_i._564_ feedback_divider_i._564_/Q clkload1/A feedback_divider_i._564_/D
+ fanout38/X VDD VSS sg13cmos5l_dfrbpq_2
Xfeedback_divider_i._495_ feedback_divider_i._495_/Q clkbuf_4_8_0_pll_clk_regs/X feedback_divider_i._503_/D
+ fanout30/X VDD VSS sg13cmos5l_dfrbpq_2
XFILLER_21_210 VDD VSS sg13cmos5l_decap_8
XFILLER_21_221 VDD VSS sg13cmos5l_fill_1
XFILLER_24_0 VDD VSS sg13cmos5l_decap_8
XFILLER_12_254 VDD VSS sg13cmos5l_decap_8
XFILLER_5_14 VDD VSS sg13cmos5l_decap_8
Xfeedback_divider_i._280_ feedback_divider_i._280_/Y feedback_divider_i._280_/A VDD
+ VSS sg13cmos5l_inv_2
Xfeedback_divider_i._547_ feedback_divider_i._547_/Q feedback_divider_i._551_/CLK
+ feedback_divider_i._547_/D fanout37/X VDD VSS sg13cmos5l_dfrbpq_2
Xfeedback_divider_i._478_ feedback_divider_i._478_/Y feedback_divider_i._490_/Q feedback_divider_i._321_/A
+ feedback_divider_i._507_/Q VDD VSS sg13cmos5l_a21oi_1
XFILLER_5_206 VDD VSS sg13cmos5l_fill_2
Xfeedback_divider_i._263_ feedback_divider_i._263_/Y feedback_divider_i._263_/A VDD
+ VSS sg13cmos5l_inv_2
Xfeedback_divider_i._332_ feedback_divider_i._594_/D feedback_divider_i._578_/Q feedback_divider_i._248_/Y
+ feedback_divider_i._331_/Y VDD VSS sg13cmos5l_o21ai_1
Xfeedback_divider_i._401_ feedback_divider_i._547_/D feedback_divider_i._499_/Q feedback_divider_i._283_/Y
+ feedback_divider_i._400_/Y VDD VSS sg13cmos5l_o21ai_1
XFILLER_4_250 VDD VSS sg13cmos5l_fill_2
Xclkbuf_2_3_0_pll_clk_regs clkbuf_3_7_0_pll_clk_regs/A clkbuf_2_3_0_pll_clk_regs/A
+ VDD VSS sg13cmos5l_buf_8
XFILLER_26_143 VDD VSS sg13cmos5l_decap_4
XFILLER_26_154 VDD VSS sg13cmos5l_fill_1
XFILLER_26_198 VDD VSS sg13cmos5l_decap_4
XFILLER_2_209 VDD VSS sg13cmos5l_decap_4
XFILLER_20_308 VDD VSS sg13cmos5l_fill_1
Xfeedback_divider_i._246_ feedback_divider_i._246_/Y feedback_divider_i._246_/A VDD
+ VSS sg13cmos5l_inv_2
Xfeedback_divider_i._315_ feedback_divider_i._315_/Y feedback_divider_i._315_/A VDD
+ VSS sg13cmos5l_inv_2
XFILLER_14_113 VDD VSS sg13cmos5l_fill_2
Xclkbuf_4_6_0_pll_clk_regs clkbuf_4_6_0_pll_clk_regs/X clkbuf_4_7_0_pll_clk_regs/A
+ VDD VSS sg13cmos5l_buf_8
Xfeedback_divider_i.configuration_decode_i._098_ feedback_divider_i._273_/A fanout42/X
+ fanout47/X feedback_divider_i.configuration_decode_i._100_/C feedback_divider_i.configuration_decode_i._153_/C
+ VDD VSS sg13cmos5l_and4_1
XFILLER_9_161 VDD VSS sg13cmos5l_decap_8
XFILLER_9_172 VDD VSS sg13cmos5l_fill_2
XFILLER_11_127 VDD VSS sg13cmos5l_decap_8
XFILLER_11_138 VDD VSS sg13cmos5l_fill_1
XFILLER_22_56 VDD VSS sg13cmos5l_fill_1
Xfeedback_divider_i._580_ feedback_divider_i._580_/Q clkbuf_4_4_0_pll_clk_regs/X feedback_divider_i._580_/D
+ fanout24/X VDD VSS sg13cmos5l_dfrbpq_2
XFILLER_10_160 VDD VSS sg13cmos5l_decap_4
XFILLER_8_25 VDD VSS sg13cmos5l_fill_1
XFILLER_0_307 VDD VSS sg13cmos5l_fill_2
XFILLER_17_23 VDD VSS sg13cmos5l_fill_1
XFILLER_15_296 VDD VSS sg13cmos5l_decap_8
Xfeedback_divider_i._563_ feedback_divider_i._563_/Q clkload1/A feedback_divider_i._563_/D
+ fanout37/X VDD VSS sg13cmos5l_dfrbpq_2
Xfeedback_divider_i._494_ feedback_divider_i._494_/Q clkbuf_4_2_0_pll_clk_regs/X feedback_divider_i._504_/D
+ fanout23/X VDD VSS sg13cmos5l_dfrbpq_2
XFILLER_17_0 VDD VSS sg13cmos5l_decap_4
XFILLER_21_233 VDD VSS sg13cmos5l_decap_8
XFILLER_21_244 VDD VSS sg13cmos5l_fill_2
XFILLER_9_90 VDD VSS sg13cmos5l_fill_2
XFILLER_12_222 VDD VSS sg13cmos5l_decap_8
XFILLER_28_22 VDD VSS sg13cmos5l_decap_8
XFILLER_28_55 VDD VSS sg13cmos5l_decap_4
XFILLER_8_226 VDD VSS sg13cmos5l_decap_8
XFILLER_8_259 VDD VSS sg13cmos5l_decap_8
XFILLER_10_7 VDD VSS sg13cmos5l_decap_8
Xfeedback_divider_i._546_ feedback_divider_i._546_/Q feedback_divider_i._551_/CLK
+ feedback_divider_i._546_/D fanout37/X VDD VSS sg13cmos5l_dfrbpq_2
Xfeedback_divider_i._477_ feedback_divider_i._509_/D feedback_divider_i._489_/Q feedback_divider_i._321_/Y
+ feedback_divider_i._476_/Y VDD VSS sg13cmos5l_o21ai_1
Xfeedback_divider_i._400_ feedback_divider_i._400_/Y feedback_divider_i._500_/Q feedback_divider_i._282_/A
+ feedback_divider_i._546_/Q VDD VSS sg13cmos5l_a21oi_1
XFILLER_4_240 VDD VSS sg13cmos5l_fill_1
XFILLER_4_262 VDD VSS sg13cmos5l_decap_8
XFILLER_4_284 VDD VSS sg13cmos5l_decap_8
Xfeedback_divider_i._262_ feedback_divider_i._262_/Y feedback_divider_i._262_/A VDD
+ VSS sg13cmos5l_inv_2
Xfeedback_divider_i._331_ feedback_divider_i._331_/Y feedback_divider_i._580_/Q feedback_divider_i._594_/Q
+ feedback_divider_i._593_/Q feedback_divider_i._579_/Q VDD VSS sg13cmos5l_a22oi_1
Xfeedback_divider_i._529_ feedback_divider_i._529_/Q clkbuf_4_8_0_pll_clk_regs/X feedback_divider_i._529_/D
+ fanout32/X VDD VSS sg13cmos5l_dfrbpq_2
XFILLER_1_221 VDD VSS sg13cmos5l_decap_4
XFILLER_26_166 VDD VSS sg13cmos5l_decap_8
XFILLER_2_49 VDD VSS sg13cmos5l_fill_2
Xclkbuf_4_14_0_pll_clk_regs feedback_divider_i._551_/CLK clkbuf_3_7_0_pll_clk_regs/X
+ VDD VSS sg13cmos5l_buf_8
Xfeedback_divider_i._314_ feedback_divider_i._314_/Y feedback_divider_i._314_/A VDD
+ VSS sg13cmos5l_inv_2
XFILLER_23_147 VDD VSS sg13cmos5l_decap_8
XFILLER_23_158 VDD VSS sg13cmos5l_fill_2
Xoutput_divider_i.div4_ff clkbuf_regs_1_div4/A output_divider_i.div4_ff/D clkload1/A
+ output_divider_i.div4_ff/D output_divider_i._4_/X VDD VSS sg13cmos5l_dfrbp_2
Xfeedback_divider_i.configuration_decode_i._097_ feedback_divider_i._272_/A fanout47/X
+ fanout60/X fanout40/X feedback_divider_i.configuration_decode_i._152_/C VDD VSS
+ sg13cmos5l_nor4_1
XFILLER_22_68 VDD VSS sg13cmos5l_fill_1
XFILLER_28_206 VDD VSS sg13cmos5l_decap_4
XFILLER_3_92 VDD VSS sg13cmos5l_decap_8
XFILLER_6_110 VDD VSS sg13cmos5l_fill_2
Xfeedback_divider_i.configuration_decode_i._149_ feedback_divider_i._317_/A feedback_divider_i.configuration_decode_i._149_/A
+ fanout12/X VDD VSS sg13cmos5l_nor2_1
XFILLER_19_4 VDD VSS sg13cmos5l_decap_8
XFILLER_17_68 VDD VSS sg13cmos5l_decap_8
XFILLER_3_135 VDD VSS sg13cmos5l_decap_8
Xfeedback_divider_i._578__69 feedback_divider_i._578_/D VDD VSS sg13cmos5l_tiehi
Xfeedback_divider_i._562_ feedback_divider_i._562_/Q feedback_divider_i._588_/CLK
+ feedback_divider_i._562_/D fanout36/X VDD VSS sg13cmos5l_dfrbpq_2
Xfeedback_divider_i._493_ feedback_divider_i._493_/Q clkbuf_4_8_0_pll_clk_regs/X feedback_divider_i._503_/D
+ fanout30/X VDD VSS sg13cmos5l_dfrbpq_2
XFILLER_0_105 VDD VSS sg13cmos5l_decap_8
XFILLER_28_78 VDD VSS sg13cmos5l_fill_2
XFILLER_5_49 VDD VSS sg13cmos5l_fill_1
Xfeedback_divider_i._545_ feedback_divider_i._545_/Q feedback_divider_i._551_/CLK
+ feedback_divider_i._545_/D fanout37/X VDD VSS sg13cmos5l_dfrbpq_2
Xfeedback_divider_i._476_ feedback_divider_i._476_/Y feedback_divider_i._490_/Q feedback_divider_i._320_/A
+ feedback_divider_i._508_/Q VDD VSS sg13cmos5l_a21oi_1
XFILLER_14_14 VDD VSS sg13cmos5l_decap_4
Xfeedback_divider_i._261_ feedback_divider_i._261_/Y feedback_divider_i._261_/A VDD
+ VSS sg13cmos5l_inv_2
Xfeedback_divider_i._330_ feedback_divider_i._595_/D feedback_divider_i._578_/Q feedback_divider_i._247_/Y
+ feedback_divider_i._329_/Y VDD VSS sg13cmos5l_o21ai_1
Xfeedback_divider_i._528_ feedback_divider_i._528_/Q clkbuf_4_8_0_pll_clk_regs/X feedback_divider_i._528_/D
+ fanout32/X VDD VSS sg13cmos5l_dfrbpq_2
Xfeedback_divider_i._459_ feedback_divider_i._518_/D feedback_divider_i._491_/Q feedback_divider_i._312_/Y
+ feedback_divider_i._458_/Y VDD VSS sg13cmos5l_o21ai_1
XFILLER_25_79 VDD VSS sg13cmos5l_decap_8
XFILLER_2_28 VDD VSS sg13cmos5l_decap_8
Xfeedback_divider_i._313_ feedback_divider_i._313_/Y feedback_divider_i._313_/A VDD
+ VSS sg13cmos5l_inv_2
XFILLER_14_115 VDD VSS sg13cmos5l_fill_1
XFILLER_28_9 VDD VSS sg13cmos5l_fill_2
XFILLER_7_0 VDD VSS sg13cmos5l_decap_8
Xfeedback_divider_i.configuration_decode_i._096_ feedback_divider_i.configuration_decode_i._152_/C
+ fanout56/X fanout54/X fanout45/X VDD VSS sg13cmos5l_nand3_1
XFILLER_22_14 VDD VSS sg13cmos5l_decap_4
XFILLER_22_47 VDD VSS sg13cmos5l_decap_8
XFILLER_3_71 VDD VSS sg13cmos5l_decap_8
XFILLER_0_7 VDD VSS sg13cmos5l_decap_8
XFILLER_12_91 VDD VSS sg13cmos5l_decap_4
XFILLER_19_207 VDD VSS sg13cmos5l_fill_1
XFILLER_6_122 VDD VSS sg13cmos5l_fill_1
Xfeedback_divider_i.configuration_decode_i._148_ feedback_divider_i._316_/A feedback_divider_i.configuration_decode_i._148_/A
+ fanout19/X fanout12/X VDD VSS sg13cmos5l_nor3_1
XFILLER_18_240 VDD VSS sg13cmos5l_decap_8
Xclkbuf_4_2_0_pll_clk_regs clkbuf_4_2_0_pll_clk_regs/X clkbuf_4_3_0_pll_clk_regs/A
+ VDD VSS sg13cmos5l_buf_8
Xfeedback_divider_i.configuration_decode_i._079_ feedback_divider_i.configuration_decode_i._155_/C
+ fanout55/X fanout53/X VDD VSS sg13cmos5l_nor2b_1
XFILLER_17_47 VDD VSS sg13cmos5l_decap_8
XFILLER_3_114 VDD VSS sg13cmos5l_decap_8
Xfeedback_divider_i._561_ feedback_divider_i._561_/Q feedback_divider_i._561_/CLK
+ feedback_divider_i._561_/D fanout35/X VDD VSS sg13cmos5l_dfrbpq_2
Xfeedback_divider_i._492_ feedback_divider_i._492_/Q clkbuf_4_0_0_pll_clk_regs/X feedback_divider_i._504_/D
+ fanout22/X VDD VSS sg13cmos5l_dfrbpq_2
XFILLER_28_35 VDD VSS sg13cmos5l_fill_2
XFILLER_9_92 VDD VSS sg13cmos5l_fill_1
XFILLER_12_268 VDD VSS sg13cmos5l_decap_4
XFILLER_5_28 VDD VSS sg13cmos5l_decap_8
XFILLER_8_217 VDD VSS sg13cmos5l_decap_4
Xfeedback_divider_i._544_ feedback_divider_i._544_/Q feedback_divider_i._597_/CLK
+ feedback_divider_i._544_/D fanout37/X VDD VSS sg13cmos5l_dfrbpq_2
Xfeedback_divider_i._475_ feedback_divider_i._510_/D feedback_divider_i._489_/Q feedback_divider_i._320_/Y
+ feedback_divider_i._474_/Y VDD VSS sg13cmos5l_o21ai_1
XFILLER_22_0 VDD VSS sg13cmos5l_decap_8
Xfeedback_divider_i._260_ feedback_divider_i._260_/Y feedback_divider_i._260_/A VDD
+ VSS sg13cmos5l_inv_2
XFILLER_20_80 VDD VSS sg13cmos5l_decap_8
XFILLER_20_91 VDD VSS sg13cmos5l_fill_1
Xfeedback_divider_i._527_ feedback_divider_i._527_/Q clkbuf_4_8_0_pll_clk_regs/X feedback_divider_i._527_/D
+ fanout30/X VDD VSS sg13cmos5l_dfrbpq_2
Xfeedback_divider_i._458_ feedback_divider_i._458_/Y feedback_divider_i._492_/Q feedback_divider_i._311_/A
+ feedback_divider_i._517_/Q VDD VSS sg13cmos5l_a21oi_1
Xfeedback_divider_i._389_ feedback_divider_i._553_/D feedback_divider_i._501_/Q feedback_divider_i._277_/Y
+ feedback_divider_i._388_/Y VDD VSS sg13cmos5l_o21ai_1
XFILLER_14_308 VDD VSS sg13cmos5l_fill_1
XFILLER_17_168 VDD VSS sg13cmos5l_decap_8
XFILLER_1_289 VDD VSS sg13cmos5l_decap_8
XFILLER_9_301 VDD VSS sg13cmos5l_decap_8
Xfeedback_divider_i._312_ feedback_divider_i._312_/Y feedback_divider_i._312_/A VDD
+ VSS sg13cmos5l_inv_2
XFILLER_11_49 VDD VSS sg13cmos5l_fill_2
XFILLER_22_182 VDD VSS sg13cmos5l_fill_2
Xclkbuf_4_10_0_pll_clk_regs feedback_divider_i._535_/CLK clkbuf_3_5_0_pll_clk_regs/X
+ VDD VSS sg13cmos5l_buf_8
Xfeedback_divider_i.configuration_decode_i._095_ feedback_divider_i._271_/A fanout50/X
+ fanout60/X fanout40/X feedback_divider_i.configuration_decode_i._151_/C VDD VSS
+ sg13cmos5l_nor4_1
XFILLER_9_131 VDD VSS sg13cmos5l_decap_4
XFILLER_9_186 VDD VSS sg13cmos5l_decap_8
XFILLER_8_17 VDD VSS sg13cmos5l_fill_2
XFILLER_18_263 VDD VSS sg13cmos5l_decap_8
Xfeedback_divider_i.configuration_decode_i._147_ feedback_divider_i._315_/A feedback_divider_i.configuration_decode_i._147_/A
+ fanout19/X fanout12/X VDD VSS sg13cmos5l_nor3_1
Xfeedback_divider_i.configuration_decode_i._078_ feedback_divider_i._262_/A fanout45/X
+ feedback_divider_i.configuration_decode_i._146_/A fanout51/X feedback_divider_i.configuration_decode_i._086_/D
+ VDD VSS sg13cmos5l_nor4_1
XFILLER_17_37 VDD VSS sg13cmos5l_decap_4
XFILLER_15_222 VDD VSS sg13cmos5l_decap_8
XFILLER_2_170 VDD VSS sg13cmos5l_fill_1
XFILLER_2_181 VDD VSS sg13cmos5l_decap_8
Xfeedback_divider_i._560_ feedback_divider_i._560_/Q clkbuf_4_6_0_pll_clk_regs/X feedback_divider_i._560_/D
+ fanout27/X VDD VSS sg13cmos5l_dfrbpq_2
Xfeedback_divider_i._491_ feedback_divider_i._491_/Q clkbuf_4_0_0_pll_clk_regs/X feedback_divider_i._503_/D
+ fanout22/X VDD VSS sg13cmos5l_dfrbpq_2
XFILLER_9_60 VDD VSS sg13cmos5l_fill_2
Xclkbuf_0_output_divider_i.div8_clk_regs clkbuf_0_output_divider_i.div8_clk_regs/X
+ clkbuf_regs_2_div8/X VDD VSS sg13cmos5l_buf_16
XFILLER_12_247 VDD VSS sg13cmos5l_decap_8
Xpfd_i._08__71 pfd_i._08_/D VDD VSS sg13cmos5l_tiehi
Xfeedback_divider_i._543_ feedback_divider_i._543_/Q feedback_divider_i._597_/CLK
+ feedback_divider_i._543_/D fanout33/X VDD VSS sg13cmos5l_dfrbpq_2
Xfeedback_divider_i._474_ feedback_divider_i._474_/Y feedback_divider_i._490_/Q feedback_divider_i._319_/A
+ feedback_divider_i._509_/Q VDD VSS sg13cmos5l_a21oi_1
XFILLER_11_280 VDD VSS sg13cmos5l_fill_1
XFILLER_15_0 VDD VSS sg13cmos5l_fill_2
XFILLER_4_298 VDD VSS sg13cmos5l_decap_8
Xfeedback_divider_i._526_ feedback_divider_i._526_/Q clkbuf_4_9_0_pll_clk_regs/X feedback_divider_i._526_/D
+ fanout30/X VDD VSS sg13cmos5l_dfrbpq_2
Xfeedback_divider_i._457_ feedback_divider_i._519_/D feedback_divider_i._491_/Q feedback_divider_i._311_/Y
+ feedback_divider_i._456_/Y VDD VSS sg13cmos5l_o21ai_1
Xfeedback_divider_i._388_ feedback_divider_i._388_/Y feedback_divider_i._502_/Q feedback_divider_i._276_/A
+ feedback_divider_i._552_/Q VDD VSS sg13cmos5l_a21oi_1
XFILLER_26_147 VDD VSS sg13cmos5l_fill_1
XFILLER_6_72 VDD VSS sg13cmos5l_fill_2
Xfeedback_divider_i._311_ feedback_divider_i._311_/Y feedback_divider_i._311_/A VDD
+ VSS sg13cmos5l_inv_2
Xfeedback_divider_i._509_ feedback_divider_i._509_/Q clkbuf_4_3_0_pll_clk_regs/X feedback_divider_i._509_/D
+ fanout21/X VDD VSS sg13cmos5l_dfrbpq_2
XFILLER_14_106 VDD VSS sg13cmos5l_decap_8
Xfeedback_divider_i.configuration_decode_i._094_ feedback_divider_i.configuration_decode_i._151_/C
+ fanout55/X fanout53/X fanout45/X VDD VSS sg13cmos5l_nand3b_1
XFILLER_26_80 VDD VSS sg13cmos5l_fill_1
XFILLER_10_164 VDD VSS sg13cmos5l_fill_1
XFILLER_12_60 VDD VSS sg13cmos5l_fill_2
Xfeedback_divider_i.configuration_decode_i._146_ feedback_divider_i._314_/A feedback_divider_i.configuration_decode_i._146_/A
+ fanout19/X fanout12/X VDD VSS sg13cmos5l_nor3_1
Xfeedback_divider_i.configuration_decode_i._077_ feedback_divider_i.configuration_decode_i._146_/A
+ fanout54/X fanout56/X VDD VSS sg13cmos5l_nand2b_1
XFILLER_17_16 VDD VSS sg13cmos5l_fill_2
Xclkbuf_1_1_0_pll_clk_regs clkbuf_2_3_0_pll_clk_regs/A clkbuf_0_pll_clk_regs/X VDD
+ VSS sg13cmos5l_buf_8
XFILLER_15_289 VDD VSS sg13cmos5l_decap_8
XFILLER_23_92 VDD VSS sg13cmos5l_fill_2
XFILLER_3_149 VDD VSS sg13cmos5l_decap_4
Xfeedback_divider_i._490_ feedback_divider_i._490_/Q clkbuf_4_0_0_pll_clk_regs/X feedback_divider_i._504_/D
+ fanout21/X VDD VSS sg13cmos5l_dfrbpq_2
XFILLER_0_74 VDD VSS sg13cmos5l_fill_2
XFILLER_17_4 VDD VSS sg13cmos5l_fill_1
XFILLER_21_226 VDD VSS sg13cmos5l_decap_8
Xfeedback_divider_i.configuration_decode_i._129_ feedback_divider_i._299_/A feedback_divider_i.configuration_decode_i._147_/A
+ fanout18/X fanout14/X VDD VSS sg13cmos5l_nor3_1
XFILLER_12_215 VDD VSS sg13cmos5l_decap_8
XFILLER_28_15 VDD VSS sg13cmos5l_decap_8
XFILLER_28_48 VDD VSS sg13cmos5l_decap_8
Xfeedback_divider_i._542_ feedback_divider_i._542_/Q clkbuf_4_9_0_pll_clk_regs/X feedback_divider_i._542_/D
+ fanout31/X VDD VSS sg13cmos5l_dfrbpq_2
XFILLER_7_263 VDD VSS sg13cmos5l_fill_1
Xfeedback_divider_i._473_ feedback_divider_i._511_/D feedback_divider_i._489_/Q feedback_divider_i._319_/Y
+ feedback_divider_i._472_/Y VDD VSS sg13cmos5l_o21ai_1
Xclkbuf_3_4_0_pll_clk_regs clkbuf_4_9_0_pll_clk_regs/A clkbuf_3_5_0_pll_clk_regs/A
+ VDD VSS sg13cmos5l_buf_8
Xfeedback_divider_i._525_ feedback_divider_i._525_/Q clkbuf_4_9_0_pll_clk_regs/X feedback_divider_i._525_/D
+ fanout30/X VDD VSS sg13cmos5l_dfrbpq_2
Xfeedback_divider_i._456_ feedback_divider_i._456_/Y feedback_divider_i._492_/Q feedback_divider_i._310_/A
+ feedback_divider_i._518_/Q VDD VSS sg13cmos5l_a21oi_1
Xfeedback_divider_i._387_ feedback_divider_i._554_/D feedback_divider_i._501_/Q feedback_divider_i._276_/Y
+ feedback_divider_i._386_/Y VDD VSS sg13cmos5l_o21ai_1
XFILLER_26_137 VDD VSS sg13cmos5l_fill_2
XFILLER_1_214 VDD VSS sg13cmos5l_decap_8
XFILLER_1_225 VDD VSS sg13cmos5l_fill_1
Xfeedback_divider_i._310_ feedback_divider_i._310_/Y feedback_divider_i._310_/A VDD
+ VSS sg13cmos5l_inv_2
Xfeedback_divider_i._508_ feedback_divider_i._508_/Q clkbuf_4_1_0_pll_clk_regs/X feedback_divider_i._508_/D
+ fanout21/X VDD VSS sg13cmos5l_dfrbpq_2
Xfeedback_divider_i._439_ feedback_divider_i._528_/D feedback_divider_i._302_/Y feedback_divider_i._493_/Q
+ feedback_divider_i._438_/Y VDD VSS sg13cmos5l_o21ai_1
Xfeedback_divider_i.configuration_decode_i._093_ feedback_divider_i._270_/A fanout50/X
+ fanout60/X fanout40/X feedback_divider_i.configuration_decode_i._150_/C VDD VSS
+ sg13cmos5l_nor4_1
XFILLER_26_92 VDD VSS sg13cmos5l_decap_8
XFILLER_3_85 VDD VSS sg13cmos5l_decap_8
XFILLER_18_221 VDD VSS sg13cmos5l_fill_2
XFILLER_5_0 VDD VSS sg13cmos5l_decap_8
XFILLER_6_103 VDD VSS sg13cmos5l_fill_2
Xfeedback_divider_i.configuration_decode_i._145_ feedback_divider_i._313_/A fanout55/X
+ fanout12/X fanout53/X fanout19/X VDD VSS sg13cmos5l_nor4_1
Xfeedback_divider_i.configuration_decode_i._076_ feedback_divider_i.configuration_decode_i._154_/C
+ fanout53/X fanout55/X VDD VSS sg13cmos5l_nor2b_1
XFILLER_18_287 VDD VSS sg13cmos5l_decap_4
XFILLER_24_213 VDD VSS sg13cmos5l_fill_1
XFILLER_5_180 VDD VSS sg13cmos5l_decap_8
XFILLER_15_213 VDD VSS sg13cmos5l_fill_2
XFILLER_15_246 VDD VSS sg13cmos5l_fill_2
XFILLER_3_106 VDD VSS sg13cmos5l_fill_2
XFILLER_3_128 VDD VSS sg13cmos5l_decap_8
XFILLER_23_60 VDD VSS sg13cmos5l_decap_8
XFILLER_2_150 VDD VSS sg13cmos5l_decap_8
XFILLER_2_161 VDD VSS sg13cmos5l_fill_2
Xfeedback_divider_i.configuration_decode_i._128_ feedback_divider_i._298_/A feedback_divider_i.configuration_decode_i._146_/A
+ fanout18/X fanout14/X VDD VSS sg13cmos5l_nor3_1
Xfeedback_divider_i.configuration_decode_i._059_ feedback_divider_i.configuration_decode_i._065_/C
+ fanout57/X fanout59/X feedback_divider_i.configuration_decode_i._054_/Y VDD VSS
+ sg13cmos5l_a21oi_1
XFILLER_18_93 VDD VSS sg13cmos5l_decap_8
Xfeedback_divider_i._541_ feedback_divider_i._541_/Q clkbuf_4_9_0_pll_clk_regs/X feedback_divider_i._541_/D
+ fanout31/X VDD VSS sg13cmos5l_dfrbpq_2
Xfeedback_divider_i._472_ feedback_divider_i._472_/Y feedback_divider_i._490_/Q feedback_divider_i._318_/A
+ feedback_divider_i._510_/Q VDD VSS sg13cmos5l_a21oi_1
XFILLER_14_18 VDD VSS sg13cmos5l_fill_2
Xfeedback_divider_i._524_ feedback_divider_i._524_/Q clkbuf_4_9_0_pll_clk_regs/X feedback_divider_i._524_/D
+ fanout30/X VDD VSS sg13cmos5l_dfrbpq_2
Xfeedback_divider_i._455_ feedback_divider_i._520_/D feedback_divider_i._310_/Y feedback_divider_i._491_/Q
+ feedback_divider_i._454_/Y VDD VSS sg13cmos5l_o21ai_1
XFILLER_20_0 VDD VSS sg13cmos5l_decap_8
XFILLER_26_105 VDD VSS sg13cmos5l_fill_2
XFILLER_6_63 VDD VSS sg13cmos5l_decap_4
XFILLER_6_74 VDD VSS sg13cmos5l_fill_1
Xfeedback_divider_i._386_ feedback_divider_i._386_/Y feedback_divider_i._502_/Q feedback_divider_i._275_/A
+ feedback_divider_i._553_/Q VDD VSS sg13cmos5l_a21oi_1
XFILLER_25_182 VDD VSS sg13cmos5l_decap_8
Xfeedback_divider_i._507_ feedback_divider_i._507_/Q clkbuf_4_1_0_pll_clk_regs/X feedback_divider_i._507_/D
+ fanout21/X VDD VSS sg13cmos5l_dfrbpq_2
Xfeedback_divider_i._438_ feedback_divider_i._438_/Y feedback_divider_i._301_/A feedback_divider_i._494_/Q
+ feedback_divider_i._527_/Q VDD VSS sg13cmos5l_a21oi_1
Xfeedback_divider_i._369_ feedback_divider_i._563_/D feedback_divider_i._503_/Q feedback_divider_i._267_/Y
+ feedback_divider_i._368_/Y VDD VSS sg13cmos5l_o21ai_1
XFILLER_22_163 VDD VSS sg13cmos5l_fill_2
XFILLER_26_71 VDD VSS sg13cmos5l_decap_8
Xfeedback_divider_i.configuration_decode_i._092_ feedback_divider_i.configuration_decode_i._150_/C
+ fanout53/X fanout45/X fanout55/X VDD VSS sg13cmos5l_nand3b_1
XFILLER_22_18 VDD VSS sg13cmos5l_fill_1
XFILLER_3_64 VDD VSS sg13cmos5l_decap_8
XFILLER_10_144 VDD VSS sg13cmos5l_decap_4
XFILLER_12_62 VDD VSS sg13cmos5l_fill_1
Xfeedback_divider_i.configuration_decode_i._144_ feedback_divider_i._312_/A fanout42/X
+ fanout48/X feedback_divider_i.configuration_decode_i._148_/A fanout12/X VDD VSS
+ sg13cmos5l_nor4_1
Xfeedback_divider_i.configuration_decode_i._075_ feedback_divider_i.configuration_decode_i._141_/D
+ fanout43/X fanout48/X VDD VSS sg13cmos5l_or2_1
XFILLER_17_18 VDD VSS sg13cmos5l_fill_1
XFILLER_18_255 VDD VSS sg13cmos5l_fill_2
XFILLER_0_21 VDD VSS sg13cmos5l_decap_8
XFILLER_0_76 VDD VSS sg13cmos5l_fill_1
XFILLER_21_217 VDD VSS sg13cmos5l_decap_4
XFILLER_23_94 VDD VSS sg13cmos5l_fill_1
XFILLER_2_195 VDD VSS sg13cmos5l_decap_8
Xfeedback_divider_i.configuration_decode_i._127_ feedback_divider_i._297_/A fanout56/X
+ fanout54/X fanout18/X fanout14/X VDD VSS sg13cmos5l_nor4_1
Xfeedback_divider_i.configuration_decode_i._058_ feedback_divider_i.configuration_decode_i._060_/B
+ fanout62/X input3/X fanout20/X VDD VSS sg13cmos5l_nor3_1
XFILLER_14_280 VDD VSS sg13cmos5l_decap_8
Xfeedback_divider_i._540_ feedback_divider_i._540_/Q clkbuf_4_9_0_pll_clk_regs/X feedback_divider_i._540_/D
+ fanout31/X VDD VSS sg13cmos5l_dfrbpq_2
Xfeedback_divider_i._471_ feedback_divider_i._512_/D feedback_divider_i._318_/Y feedback_divider_i._489_/Q
+ feedback_divider_i._470_/Y VDD VSS sg13cmos5l_o21ai_1
XFILLER_4_246 VDD VSS sg13cmos5l_decap_4
XFILLER_6_42 VDD VSS sg13cmos5l_decap_8
Xfeedback_divider_i._523_ feedback_divider_i._523_/Q clkbuf_4_2_0_pll_clk_regs/X feedback_divider_i._523_/D
+ fanout23/X VDD VSS sg13cmos5l_dfrbpq_2
Xfeedback_divider_i._454_ feedback_divider_i._454_/Y feedback_divider_i._309_/A feedback_divider_i._492_/Q
+ feedback_divider_i._519_/Q VDD VSS sg13cmos5l_a21oi_1
Xfeedback_divider_i._385_ feedback_divider_i._555_/D feedback_divider_i._501_/Q feedback_divider_i._275_/Y
+ feedback_divider_i._384_/Y VDD VSS sg13cmos5l_o21ai_1
XFILLER_13_0 VDD VSS sg13cmos5l_decap_8
XFILLER_25_29 VDD VSS sg13cmos5l_fill_1
Xclkbuf_3_0_0_pll_clk_regs clkbuf_4_1_0_pll_clk_regs/A clkbuf_3_1_0_pll_clk_regs/A
+ VDD VSS sg13cmos5l_buf_8
XFILLER_0_271 VDD VSS sg13cmos5l_fill_1
XFILLER_13_301 VDD VSS sg13cmos5l_decap_8
Xfeedback_divider_i._506_ feedback_divider_i._506_/Q clkbuf_4_1_0_pll_clk_regs/X feedback_divider_i._506_/D
+ fanout21/X VDD VSS sg13cmos5l_dfrbpq_2
Xfeedback_divider_i._437_ feedback_divider_i._529_/D feedback_divider_i._495_/Q feedback_divider_i._301_/Y
+ feedback_divider_i._436_/Y VDD VSS sg13cmos5l_o21ai_1
Xfeedback_divider_i._368_ feedback_divider_i._368_/Y feedback_divider_i._504_/Q feedback_divider_i._266_/A
+ feedback_divider_i._562_/Q VDD VSS sg13cmos5l_a21oi_1
Xfeedback_divider_i._299_ feedback_divider_i._299_/Y feedback_divider_i._299_/A VDD
+ VSS sg13cmos5l_inv_2
XFILLER_13_153 VDD VSS sg13cmos5l_fill_2
XFILLER_6_308 VDD VSS sg13cmos5l_fill_1
XFILLER_9_135 VDD VSS sg13cmos5l_fill_1
Xfeedback_divider_i.configuration_decode_i._091_ feedback_divider_i._269_/A fanout61/X
+ fanout41/X feedback_divider_i.configuration_decode_i._149_/A VDD VSS sg13cmos5l_nor3_1
XFILLER_3_21 VDD VSS sg13cmos5l_decap_4
XFILLER_9_168 VDD VSS sg13cmos5l_decap_4
XFILLER_9_179 VDD VSS sg13cmos5l_fill_2
XFILLER_12_41 VDD VSS sg13cmos5l_decap_8
XFILLER_6_105 VDD VSS sg13cmos5l_fill_1
Xclkbuf_1_0_0_output_divider_i.div8_clk_regs output_divider_i.div16_ff/CLK clkbuf_0_output_divider_i.div8_clk_regs/X
+ VDD VSS sg13cmos5l_buf_8
Xfeedback_divider_i.configuration_decode_i._143_ feedback_divider_i._311_/A fanout42/X
+ fanout12/X fanout48/X feedback_divider_i.configuration_decode_i._147_/A VDD VSS
+ sg13cmos5l_nor4_1
Xfeedback_divider_i.configuration_decode_i._074_ feedback_divider_i.configuration_decode_i._086_/D
+ fanout61/X fanout41/X VDD VSS sg13cmos5l_or2_1
Xclkbuf_regs_0_half clkbuf_regs_0_half/X pll_clk VDD VSS sg13cmos5l_buf_16
XFILLER_3_108 VDD VSS sg13cmos5l_fill_1
XFILLER_15_215 VDD VSS sg13cmos5l_fill_1
XFILLER_15_248 VDD VSS sg13cmos5l_fill_1
XFILLER_23_281 VDD VSS sg13cmos5l_fill_2
XFILLER_2_130 VDD VSS sg13cmos5l_fill_2
Xclkbuf_4_9_0_pll_clk_regs clkbuf_4_9_0_pll_clk_regs/X clkbuf_4_9_0_pll_clk_regs/A
+ VDD VSS sg13cmos5l_buf_8
Xfeedback_divider_i.configuration_decode_i._126_ feedback_divider_i._296_/A fanout45/X
+ fanout51/X feedback_divider_i.configuration_decode_i._148_/A fanout14/X VDD VSS
+ sg13cmos5l_nor4_1
Xfeedback_divider_i.configuration_decode_i._057_ feedback_divider_i.configuration_decode_i._072_/A
+ fanout62/X fanout58/X VDD VSS sg13cmos5l_nor2_1
XFILLER_28_29 VDD VSS sg13cmos5l_fill_2
Xfeedback_divider_i._470_ feedback_divider_i._470_/Y feedback_divider_i._317_/A feedback_divider_i._490_/Q
+ feedback_divider_i._511_/Q VDD VSS sg13cmos5l_a21oi_1
XFILLER_7_211 VDD VSS sg13cmos5l_decap_4
Xfeedback_divider_i.configuration_decode_i._109_ feedback_divider_i._281_/A input5/X
+ input6/X fanout18/X fanout17/X VDD VSS sg13cmos5l_nor4_1
XFILLER_4_203 VDD VSS sg13cmos5l_fill_2
XFILLER_4_236 VDD VSS sg13cmos5l_decap_4
XFILLER_4_269 VDD VSS sg13cmos5l_fill_1
Xfeedback_divider_i._522_ feedback_divider_i._522_/Q clkbuf_4_8_0_pll_clk_regs/X feedback_divider_i._522_/D
+ fanout30/X VDD VSS sg13cmos5l_dfrbpq_2
Xfeedback_divider_i._453_ feedback_divider_i._521_/D feedback_divider_i._493_/Q feedback_divider_i._309_/Y
+ feedback_divider_i._452_/Y VDD VSS sg13cmos5l_o21ai_1
Xfeedback_divider_i._384_ feedback_divider_i._384_/Y feedback_divider_i._502_/Q feedback_divider_i._274_/A
+ feedback_divider_i._554_/Q VDD VSS sg13cmos5l_a21oi_1
Xfeedback_divider_i._505_ feedback_divider_i._505_/Q clkbuf_4_1_0_pll_clk_regs/X feedback_divider_i._505_/D
+ fanout21/X VDD VSS sg13cmos5l_dfrbpq_2
Xfeedback_divider_i._298_ feedback_divider_i._298_/Y feedback_divider_i._298_/A VDD
+ VSS sg13cmos5l_inv_2
Xfeedback_divider_i._436_ feedback_divider_i._436_/Y feedback_divider_i._496_/Q feedback_divider_i._300_/A
+ feedback_divider_i._528_/Q VDD VSS sg13cmos5l_a21oi_1
Xfeedback_divider_i._367_ feedback_divider_i._564_/D feedback_divider_i._503_/Q feedback_divider_i._266_/Y
+ feedback_divider_i._366_/Y VDD VSS sg13cmos5l_o21ai_1
XFILLER_26_51 VDD VSS sg13cmos5l_fill_1
Xfeedback_divider_i.configuration_decode_i._090_ feedback_divider_i.configuration_decode_i._149_/A
+ fanout47/X feedback_divider_i.configuration_decode_i._153_/C fanout42/X VDD VSS
+ sg13cmos5l_nand3b_1
XFILLER_3_99 VDD VSS sg13cmos5l_decap_8
Xfeedback_divider_i._419_ feedback_divider_i._538_/D feedback_divider_i._497_/Q feedback_divider_i._292_/Y
+ feedback_divider_i._418_/Y VDD VSS sg13cmos5l_o21ai_1
Xfeedback_divider_i.configuration_decode_i._142_ feedback_divider_i._310_/A fanout42/X
+ fanout12/X fanout48/X feedback_divider_i.configuration_decode_i._146_/A VDD VSS
+ sg13cmos5l_nor4_1
XFILLER_12_75 VDD VSS sg13cmos5l_fill_2
XFILLER_18_257 VDD VSS sg13cmos5l_fill_1
Xfeedback_divider_i.configuration_decode_i._073_ feedback_divider_i.configuration_decode_i._100_/C
+ fanout60/X fanout40/X VDD VSS sg13cmos5l_nor2_1
XFILLER_24_205 VDD VSS sg13cmos5l_decap_4
XFILLER_23_85 VDD VSS sg13cmos5l_decap_8
XFILLER_3_0 VDD VSS sg13cmos5l_decap_8
Xfeedback_divider_i.configuration_decode_i._125_ feedback_divider_i._295_/A fanout45/X
+ fanout51/X feedback_divider_i.configuration_decode_i._147_/A fanout14/X VDD VSS
+ sg13cmos5l_nor4_1
Xfeedback_divider_i.configuration_decode_i._056_ feedback_divider_i._250_/A feedback_divider_i.configuration_decode_i._072_/C
+ fanout20/X feedback_divider_i.configuration_decode_i._055_/Y VDD VSS sg13cmos5l_a21oi_1
XFILLER_0_67 VDD VSS sg13cmos5l_decap_8
XFILLER_14_260 VDD VSS sg13cmos5l_fill_2
XFILLER_18_63 VDD VSS sg13cmos5l_fill_2
XFILLER_20_263 VDD VSS sg13cmos5l_fill_2
XFILLER_7_245 VDD VSS sg13cmos5l_fill_2
Xfeedback_divider_i.configuration_decode_i._108_ feedback_divider_i._280_/A fanout46/X
+ fanout52/X feedback_divider_i.configuration_decode_i._148_/A fanout17/X VDD VSS
+ sg13cmos5l_nor4_1
XFILLER_28_171 VDD VSS sg13cmos5l_decap_8
Xfeedback_divider_i._521_ feedback_divider_i._521_/Q clkbuf_4_8_0_pll_clk_regs/X feedback_divider_i._521_/D
+ fanout30/X VDD VSS sg13cmos5l_dfrbpq_2
Xfeedback_divider_i._452_ feedback_divider_i._452_/Y feedback_divider_i._494_/Q feedback_divider_i._308_/A
+ feedback_divider_i._520_/Q VDD VSS sg13cmos5l_a21oi_1
Xfeedback_divider_i._383_ feedback_divider_i._556_/D feedback_divider_i._501_/Q feedback_divider_i._274_/Y
+ feedback_divider_i._382_/Y VDD VSS sg13cmos5l_o21ai_1
XFILLER_0_251 VDD VSS sg13cmos5l_decap_8
XFILLER_16_196 VDD VSS sg13cmos5l_fill_2
Xfeedback_divider_i._297_ feedback_divider_i._297_/Y feedback_divider_i._297_/A VDD
+ VSS sg13cmos5l_inv_2
Xfeedback_divider_i._504_ feedback_divider_i._504_/Q feedback_divider_i._561_/CLK
+ feedback_divider_i._504_/D fanout35/X VDD VSS sg13cmos5l_dfrbpq_2
Xfeedback_divider_i._435_ feedback_divider_i._530_/D feedback_divider_i._495_/Q feedback_divider_i._300_/Y
+ feedback_divider_i._434_/Y VDD VSS sg13cmos5l_o21ai_1
Xfeedback_divider_i._366_ feedback_divider_i._366_/Y feedback_divider_i._504_/Q feedback_divider_i._265_/A
+ feedback_divider_i._563_/Q VDD VSS sg13cmos5l_a21oi_1
.ends
